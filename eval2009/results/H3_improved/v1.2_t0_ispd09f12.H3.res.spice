* spice from ispd09f12.H3.res
.include /home/mark/smart.pnrVLSI/ispd09CNS_results/ispd09_benchmarks/tuned_45nm_HP.pm
.subckt inv0 in out vdd
m1  out in  vdd vdd   pmos l=45n w=14.6u
m2  out in  0   0     nmos l=45n w=10.0u
.ends inv0
.subckt inv1 in out vdd
m1  out in  vdd vdd   pmos l=45n w=2.0u
m2  out in  0   0     nmos l=45n w=1.37u
.ends inv1
c0 n0 0 0f
c1 n117 0 47.09f
c2 n118 0 26.5966f
c3 n119 0 29.7809f
c4 n120 0 26.78935f
c5 n121 0 47.39575f
c6 n122 0 25.2932f
c7 n123 0 44.90025f
c8 n124 0 34.84855f
c9 n125 0 48.2054f
c10 n126 0 42.27555f
c11 n127 0 43.768f
c12 n128 0 28.69885f
c13 n129 0 41.69745f
c14 n130 0 47.2781f
c15 n131 0 39.042f
c16 n132 0 49.16975f
c17 n133 0 40.72995f
c18 n134 0 38.22305f
c19 n135 0 37.507f
c20 n136 0 40.86765f
c21 n137 0 44.6396f
c22 n138 0 42.0052f
c23 n139 0 30.3964f
c24 n140 0 30.4614f
c25 n141 0 26.23305f
c26 n142 0 47.59185f
c27 n143 0 42.9654f
c28 n144 0 45.09005f
c29 n145 0 7.67315f
c30 n146 0 22.92065f
c31 n147 0 41.23705f
c32 n148 0 43.4177f
c33 n149 0 29.18045f
c34 n150 0 27.5241f
c35 n151 0 26.59145f
c36 n152 0 41.5878f
c37 n153 0 40.10975f
c38 n154 0 40.95865f
c39 n155 0 40.9401f
c40 n156 0 45.1996f
c41 n157 0 28.2667f
c42 n158 0 27.12505f
c43 n159 0 42.72005f
c44 n160 0 41.758975f
c45 n161 0 31.3747f
c46 n162 0 33.61055f
c47 n163 0 30.75135f
c48 n164 0 6.443725f
c49 n165 0 41.97075f
c50 n166 0 41.69155f
c51 n167 0 43.4356f
c52 n168 0 45.9135f
c53 n169 0 28.4f
c54 n170 0 0f
c55 n171 0 35.31465f
c56 n172 0 37.82705f
c57 n173 0 29.4193f
c58 n174 0 32.8883f
c59 n175 0 0f
c60 n176 0 46.18205f
c61 n177 0 39.14165f
c62 n178 0 38.19185f
c63 n179 0 47.46375f
c64 n180 0 41.2399f
c65 n181 0 36.05305f
c66 n182 0 37.68885f
c67 n183 0 43.0884f
c68 n184 0 34.29205f
c69 n185 0 44.83965f
c70 n186 0 42.0054f
c71 n187 0 42.1853f
c72 n188 0 45.907325f
c73 n189 0 17.7653f
c74 n190 0 0f
c75 n191 0 49.0588f
c76 n192 0 48.30135f
c77 n193 0 0f
c78 n194 0 48.654725f
c79 n195 0 43.01555f
c80 n196 0 33.55825f
c81 n197 0 0f
c82 n198 0 14.558825f
c83 n199 0 44.0459f
c84 n200 0 0f
c85 n201 0 0f
c86 n202 0 0f
c87 n203 0 42.4754f
c88 n204 0 31.787775f
c89 n205 0 43.57355f
c90 n206 0 0f
c91 n207 0 40.63015f
c92 n208 0 27.3883f
c93 n209 0 0f
c94 n210 0 44.74955f
c95 n211 0 0f
c96 n212 0 0f
c97 n213 0 42.768575f
c98 n214 0 34.218875f
c99 n215 0 0f
c100 n216 0 38.9169f
c101 n217 0 0f
c102 n218 0 33.9069f
c103 n219 0 45.650875f
c104 n220 0 41.59025f
c105 n221 0 45.31595f
c106 n222 0 42.9299f
c107 n223 0 46.134175f
c108 n224 0 0f
c109 n225 0 39.847175f
c110 n226 0 42.213675f
c111 n227 0 33.76745f
c112 n228 0 0f
c113 n229 0 44.89915f
c114 n230 0 49.803425f
c115 n231 0 0f
c116 n232 0 47.922025f
c117 n351 0 47.9242f
c118 n353 0 41.7591f
c119 n354 0 37.2602f
c120 n357 0 27.5241f
c121 n358 0 45.64245f
c122 n359 0 45.64245f
c123 n360 0 41.2399f
c124 n361 0 44.046f
c125 n362 0 44.6396f
c126 n363 0 0f
c127 n364 0 43.0041f
c128 n365 0 41.36855f
c129 n366 0 41.36855f
c130 n367 0 0f
c131 n368 0 45.8102f
c132 n369 0 40.9401f
c133 n370 0 25.3401f
c134 n371 0 25.3401f
c135 n372 0 46.135f
c136 n373 0 45.9078f
c137 n374 0 33.7675f
c138 n376 0 27.3319f
c139 n378 0 44.9002f
c140 n379 0 49.804f
c141 n381 0 6.443725f
c142 n382 0 41.2372f
c143 n383 0 42.0053f
c144 n384 0 43.0143f
c145 n385 0 43.0143f
c146 n386 0 44.55055f
c147 n387 0 44.55055f
c148 n388 0 48.6548f
c149 n390 0 42.214f
c150 n391 0 43.0162f
c151 n392 0 42.7688f
c152 n393 0 39.8476f
c153 n394 0 34.8488f
c154 n395 0 17.7653f
c155 n396 0 0f
c156 n397 0 33.3769f
c157 n399 0 43.4358f
c158 n400 0 42.9301f
c159 n401 0 0f
c160 n402 0 43.2223f
c161 n403 0 48.2054f
c162 n404 0 38.239f
c163 n405 0 38.239f
c164 n406 0 25.2934f
c165 n407 0 30.75135f
c166 n408 0 27.088f
c167 n409 0 27.088f
c168 n410 0 34.3407f
c169 n411 0 34.3407f
c170 n412 0 0f
c171 n413 0 37.52485f
c172 n414 0 0f
c173 n415 0 37.52485f
c174 n416 0 37.507f
c175 n418 0 41.971f
c176 n419 0 27.3883f
c177 n420 0 49.0588f
c178 n421 0 42.9655f
c179 n422 0 0f
c180 n423 0 42.61655f
c181 n424 0 0f
c182 n425 0 42.61655f
c183 n426 0 0f
c184 n427 0 39.7444f
c185 n428 0 27.12505f
c186 n429 0 26.1819f
c187 n430 0 26.1818f
c188 n431 0 28.7057f
c189 n432 0 28.7057f
c190 n433 0 0f
c191 n434 0 39.94095f
c192 n435 0 0f
c193 n436 0 39.94095f
c194 n437 0 40.6305f
c195 n438 0 46.1821f
c196 n440 0 30.1329f
c197 n441 0 0f
c198 n442 0 27.0202f
c199 n444 0 42.0058f
c200 n445 0 40.9589f
c201 n446 0 26.7894f
c202 n447 0 40.10975f
c203 n448 0 48.3675f
c204 n449 0 48.3675f
c205 n450 0 34.8985f
c206 n451 0 34.8985f
c207 n452 0 0f
c208 n453 0 42.6684f
c209 n454 0 7.67315f
c210 n455 0 38.8319f
c211 n456 0 39.042f
c212 n457 0 0f
c213 n458 0 38.62155f
c214 n459 0 0f
c215 n460 0 38.62155f
c216 n461 0 34.2924f
c217 n462 0 44.83965f
c218 n463 0 39.1418f
c219 n464 0 43.0884f
c220 n465 0 26.5915f
c221 n466 0 28.6991f
c222 n467 0 0f
c223 n468 0 38.2545f
c224 n469 0 0f
c225 n470 0 38.2545f
c226 n471 0 0f
c227 n472 0 42.4695f
c228 n473 0 0f
c229 n474 0 42.4695f
c230 n475 0 30.2287f
c231 n476 0 30.2287f
c232 n477 0 0f
c233 n478 0 40.3519f
c234 n479 0 41.69745f
c235 n480 0 39.0062f
c236 n481 0 39.0062f
c237 n482 0 37.82705f
c238 n483 0 48.30135f
c239 n484 0 0f
c240 n485 0 25.825f
c241 n486 0 0f
c242 n487 0 25.825f
c243 n488 0 0f
c244 n489 0 31.0621f
c245 n490 0 0f
c246 n491 0 31.0622f
c247 n492 0 28.2667f
c248 n494 0 45.651f
c249 n495 0 42.1853f
c250 n496 0 44.75f
c251 n497 0 41.5904f
c252 n498 0 45.1999f
c253 n499 0 42.4754f
c254 n500 0 47.5919f
c255 n501 0 35.31465f
c256 n502 0 29.1806f
c257 n503 0 45.9135f
c258 n504 0 28.8497f
c259 n505 0 28.8497f
c260 n506 0 45.25175f
c261 n507 0 45.25175f
c262 n508 0 0f
c263 n509 0 43.7437f
c264 n510 0 0f
c265 n511 0 43.7437f
c266 n512 0 26.5968f
c267 n513 0 43.4177f
c268 n514 0 0f
c269 n515 0 44.86115f
c270 n516 0 0f
c271 n517 0 44.86115f
c272 n518 0 0f
c273 n519 0 35.08545f
c274 n520 0 0f
c275 n521 0 35.08545f
c276 n522 0 42.27555f
c277 n524 0 44.9005f
c278 n525 0 45.0902f
c279 n526 0 47.09f
c280 n527 0 40.86765f
c281 n528 0 39.69165f
c282 n529 0 39.69165f
c283 n530 0 33.4693f
c284 n531 0 33.4693f
c285 n532 0 0f
c286 n533 0 36.0383f
c287 n534 0 0f
c288 n535 0 36.0383f
c289 n536 0 36.7844f
c290 n537 0 36.7844f
c291 n539 0 14.558825f
c292 n540 0 0f
c293 n541 0 37.3547f
c294 n543 0 39.211f
c295 n544 0 39.211f
c296 n545 0 34.219f
c297 n546 0 31.7879f
c298 n547 0 47.2782f
c299 n548 0 38.1919f
c300 n549 0 0f
c301 n550 0 33.3118f
c302 n551 0 0f
c303 n552 0 33.3118f
c304 n553 0 0f
c305 n554 0 39.3647f
c306 n555 0 0f
c307 n556 0 39.3647f
c308 n557 0 22.92065f
c309 n559 0 37.6891f
c310 n560 0 42.7202f
c311 n561 0 46.7243f
c312 n562 0 46.7243f
c313 n563 0 34.8461f
c314 n564 0 28.4f
c315 n565 0 0f
c316 n566 0 47.7379f
c317 n567 0 0f
c318 n568 0 47.7379f
c319 n569 0 0f
c320 n570 0 43.7104f
c321 n571 0 0f
c322 n572 0 43.7104f
c323 n573 0 0f
c324 n574 0 26.6044f
c325 n575 0 0f
c326 n576 0 26.6044f
c327 n577 0 38.2231f
c328 n578 0 40.7302f
c329 n579 0 0f
c330 n580 0 41.20465f
c331 n581 0 0f
c332 n582 0 41.20465f
c333 n583 0 0f
c334 n584 0 9.83655f
c335 n586 0 43.8075f
c336 n587 0 43.8076f
c337 n588 0 45.31595f
c338 n589 0 43.5737f
c339 n590 0 36.0532f
c340 n591 0 33.5586f
c341 n592 0 30.4616f
c342 n593 0 41.5879f
c343 n594 0 48.70655f
c344 n595 0 48.70655f
c345 n596 0 43.768f
c346 n597 0 30.3964f
c347 n598 0 0f
c348 n599 0 40.56285f
c349 n600 0 0f
c350 n601 0 40.56285f
c351 n602 0 0f
c352 n603 0 27.19125f
c353 n604 0 0f
c354 n605 0 27.19125f
c355 n606 0 29.4194f
c356 n607 0 32.8886f
c357 n608 0 29.3107f
c358 n609 0 29.3107f
c359 n610 0 32.7798f
c360 n611 0 29.7809f
c361 n612 0 0f
c362 n613 0 35.77865f
c363 n614 0 0f
c364 n615 0 35.77865f
c365 n616 0 47.4641f
c366 n617 0 33.9071f
c367 n618 0 41.6918f
c368 n619 0 38.917f
c369 n620 0 26.2331f
c370 n621 0 47.4171f
c371 n622 0 0f
c372 n623 0 42.36785f
c373 n624 0 0f
c374 n625 0 42.36785f
c375 n626 0 49.16975f
c376 n627 0 33.61055f
c377 n628 0 0f
c378 n629 0 27.8371f
c379 n630 0 0f
c380 n631 0 27.837f
c381 n632 0 0f
c382 n633 0 40.1148f
c383 n634 0 0f
c384 n635 0 40.1148f
c385 n636 0 31.3747f
c386 n637 0 47.39575f
c387 n638 0 37.1372f
c388 n639 0 37.1372f
c389 n640 0 26.5792f
c390 n641 0 26.5792f
c391 n234 0 77.6683f
c392 n235 0 73.62155f
c393 n236 0 75.35175f
c394 n237 0 65.2287f
c395 n238 0 65.2287f
c396 n239 0 76.36855f
c397 n240 0 72.26015f
c398 n241 0 80.81005f
c399 n242 0 77.36785f
c400 n243 0 75.1148f
c401 n244 0 75.1148f
c402 n245 0 72.1372f
c403 n246 0 61.57905f
c404 n247 0 73.83165f
c405 n248 0 73.62155f
c406 n249 0 74.0062f
c407 n250 0 73.2545f
c408 n251 0 77.4695f
c409 n252 0 76.36855f
c410 n253 0 80.64245f
c411 n254 0 60.34005f
c412 n255 0 77.36785f
c413 n256 0 62.8369f
c414 n257 0 62.837f
c415 n258 0 72.1372f
c416 n259 0 61.57905f
c417 n260 0 65.1329f
c418 n261 0 62.02f
c419 n262 0 74.0062f
c420 n263 0 73.2545f
c421 n264 0 77.4695f
c422 n265 0 78.00405f
c423 n266 0 80.64245f
c424 n267 0 60.34005f
c425 n268 0 82.4169f
c426 n269 0 83.70655f
c427 n270 0 83.70655f
c428 n271 0 64.31065f
c429 n272 0 64.31065f
c430 n273 0 83.3675f
c431 n274 0 83.3675f
c432 n275 0 79.55055f
c433 n276 0 79.55055f
c434 n277 0 78.80735f
c435 n278 0 44.83655f
c436 n279 0 74.69165f
c437 n280 0 74.69165f
c438 n281 0 71.7844f
c439 n282 0 75.56285f
c440 n283 0 62.19125f
c441 n284 0 70.77865f
c442 n285 0 70.77865f
c443 n286 0 69.8985f
c444 n287 0 69.8985f
c445 n288 0 78.0143f
c446 n289 0 60.8249f
c447 n290 0 60.8249f
c448 n291 0 78.80745f
c449 n292 0 68.4693f
c450 n293 0 68.4693f
c451 n294 0 71.7844f
c452 n295 0 75.56285f
c453 n296 0 62.19125f
c454 n297 0 67.77975f
c455 n298 0 81.7243f
c456 n299 0 63.7056f
c457 n300 0 63.7056f
c458 n301 0 78.0143f
c459 n302 0 66.0621f
c460 n303 0 66.062f
c461 n304 0 76.20465f
c462 n305 0 62.33175f
c463 n306 0 71.0383f
c464 n307 0 71.0383f
c465 n308 0 74.3647f
c466 n309 0 74.3647f
c467 n310 0 72.3547f
c468 n311 0 81.7243f
c469 n312 0 74.94095f
c470 n313 0 74.94095f
c471 n314 0 73.239f
c472 n315 0 73.239f
c473 n316 0 78.2221f
c474 n317 0 76.20465f
c475 n318 0 78.7437f
c476 n319 0 78.7437f
c477 n320 0 61.6042f
c478 n321 0 61.6042f
c479 n322 0 74.2109f
c480 n323 0 78.7104f
c481 n324 0 78.7104f
c482 n325 0 74.74425f
c483 n326 0 77.61655f
c484 n327 0 77.61655f
c485 n328 0 68.3769f
c486 n329 0 69.3407f
c487 n330 0 69.3407f
c488 n331 0 63.8496f
c489 n332 0 80.25175f
c490 n333 0 70.08545f
c491 n334 0 70.08545f
c492 n335 0 68.31175f
c493 n336 0 74.2109f
c494 n337 0 82.7379f
c495 n338 0 61.1817f
c496 n339 0 61.1818f
c497 n340 0 72.52485f
c498 n341 0 72.52485f
c499 n342 0 62.08795f
c500 n343 0 62.08795f
c501 n344 0 63.8496f
c502 n345 0 80.25175f
c503 n346 0 79.86115f
c504 n347 0 79.86115f
c505 n348 0 68.31175f
c506 n349 0 69.8457f
c507 n350 0 82.7379f
c508 nSEG_NODE_525 0 95.8484f
c509 nSEG_NODE_526 0 95.8484f
c510 nSEG_NODE_527 0 95.8484f
c511 nSEG_NODE_528 0 95.8484f
c512 nSEG_NODE_529 0 95.8484f
c513 nSEG_NODE_530 0 95.8484f
c514 nSEG_NODE_531 0 95.8484f
c515 nSEG_NODE_532 0 95.8484f
c516 nSEG_NODE_533 0 95.8484f
c517 nSEG_NODE_534 0 95.8484f
c518 nSEG_NODE_535 0 95.8484f
c519 nSEG_NODE_536 0 95.8484f
c520 nSEG_NODE_537 0 95.8484f
c521 nSEG_NODE_538 0 95.8484f
c522 nSEG_NODE_539 0 95.8484f
c523 nSEG_NODE_540 0 95.846225f
c524 nSEG_NODE_541 0 83.518075f
c525 nSEG_NODE_542 0 74.52035f
c526 nSEG_NODE_543 0 55.0482f
c527 nSEG_NODE_544 0 82.4798f
c528 nSEG_NODE_545 0 88.0919f
c529 nSEG_NODE_546 0 86.00815f
c530 nSEG_NODE_547 0 91.62025f
c531 nSEG_NODE_548 0 50.68015f
c532 nSEG_NODE_549 0 50.68015f
c533 nSEG_NODE_550 0 92.27f
c534 nSEG_NODE_551 0 92.27f
c535 nSEG_NODE_552 0 92.27f
c536 nSEG_NODE_553 0 92.27f
c537 nSEG_NODE_554 0 92.27f
c538 nSEG_NODE_555 0 92.27f
c539 nSEG_NODE_556 0 92.27f
c540 nSEG_NODE_557 0 92.269175f
c541 nSEG_NODE_558 0 91.8156f
c542 nSEG_NODE_559 0 91.8156f
c543 nSEG_NODE_560 0 91.8156f
c544 nSEG_NODE_561 0 91.815125f
c545 nSEG_NODE_562 0 67.53495f
c546 nSEG_NODE_563 0 54.66365f
c547 nSEG_NODE_564 0 89.8004f
c548 nSEG_NODE_565 0 89.8004f
c549 nSEG_NODE_566 0 89.8004f
c550 nSEG_NODE_567 0 89.8004f
c551 nSEG_NODE_568 0 89.8004f
c552 nSEG_NODE_569 0 89.8004f
c553 nSEG_NODE_570 0 89.8004f
c554 nSEG_NODE_571 0 89.79935f
c555 nSEG_NODE_572 0 99.608f
c556 nSEG_NODE_573 0 99.608f
c557 nSEG_NODE_574 0 99.608f
c558 nSEG_NODE_575 0 99.608f
c559 nSEG_NODE_576 0 99.608f
c560 nSEG_NODE_577 0 99.607425f
c561 nSEG_NODE_578 0 82.47425f
c562 nSEG_NODE_579 0 84.0105f
c563 nSEG_NODE_580 0 97.3096f
c564 nSEG_NODE_581 0 97.309525f
c565 nSEG_NODE_582 0 84.428f
c566 nSEG_NODE_583 0 84.428f
c567 nSEG_NODE_584 0 84.428f
c568 nSEG_NODE_585 0 84.427675f
c569 nSEG_NODE_586 0 86.0324f
c570 nSEG_NODE_587 0 86.0324f
c571 nSEG_NODE_588 0 86.0324f
c572 nSEG_NODE_589 0 86.03175f
c573 nSEG_NODE_590 0 85.5376f
c574 nSEG_NODE_591 0 85.5376f
c575 nSEG_NODE_592 0 85.537375f
c576 nSEG_NODE_593 0 79.6952f
c577 nSEG_NODE_594 0 79.6952f
c578 nSEG_NODE_595 0 79.694775f
c579 nSEG_NODE_596 0 69.6976f
c580 nSEG_NODE_597 0 69.69735f
c581 nSEG_NODE_598 0 86.8716f
c582 nSEG_NODE_599 0 86.8714f
c583 nSEG_NODE_600 0 85.8602f
c584 nSEG_NODE_601 0 85.86f
c585 nSEG_NODE_602 0 86.4444f
c586 nSEG_NODE_603 0 50.5866f
c587 nSEG_NODE_604 0 54.17595f
c588 nSEG_NODE_605 0 54.17595f
c589 nSEG_NODE_606 0 83.942f
c590 nSEG_NODE_607 0 83.94175f
c591 nSEG_NODE_608 0 54.7766f
c592 nSEG_NODE_609 0 85.9309f
c593 nSEG_NODE_610 0 79.48865f
c594 nSEG_NODE_611 0 52.3636f
c595 nSEG_NODE_612 0 52.3636f
c596 nSEG_NODE_613 0 57.4113f
c597 nSEG_NODE_614 0 57.4113f
c598 nSEG_NODE_615 0 81.261f
c599 nSEG_NODE_616 0 81.26065f
c600 nSEG_NODE_617 0 92.3642f
c601 nSEG_NODE_618 0 92.3642f
c602 nSEG_NODE_619 0 92.36415f
c603 nSEG_NODE_620 0 54.0402f
c604 nSEG_NODE_621 0 84.0116f
c605 nSEG_NODE_622 0 84.0112f
c606 nSEG_NODE_623 0 81.9178f
c607 nSEG_NODE_624 0 81.91755f
c608 nSEG_NODE_625 0 53.57875f
c609 nSEG_NODE_626 0 85.3367f
c610 nSEG_NODE_627 0 77.66355f
c611 nSEG_NODE_628 0 68.5848f
c612 nSEG_NODE_629 0 68.58445f
c613 nSEG_NODE_630 0 78.28345f
c614 nSEG_NODE_631 0 53.18295f
c615 nSEG_NODE_632 0 57.39795f
c616 nSEG_NODE_633 0 60.4574f
c617 nSEG_NODE_634 0 60.4574f
c618 nSEG_NODE_635 0 80.70365f
c619 nSEG_NODE_636 0 51.6499f
c620 nSEG_NODE_637 0 51.6499f
c621 nSEG_NODE_638 0 62.1242f
c622 nSEG_NODE_639 0 62.1242f
c623 nSEG_NODE_640 0 91.302f
c624 nSEG_NODE_641 0 91.302f
c625 nSEG_NODE_642 0 91.302f
c626 nSEG_NODE_643 0 91.301875f
c627 nSEG_NODE_644 0 84.3706f
c628 nSEG_NODE_645 0 89.5f
c629 nSEG_NODE_646 0 89.5f
c630 nSEG_NODE_647 0 89.5f
c631 nSEG_NODE_648 0 89.49955f
c632 nSEG_NODE_649 0 83.1808f
c633 nSEG_NODE_650 0 83.18065f
c634 nSEG_NODE_651 0 90.3998f
c635 nSEG_NODE_652 0 90.3995f
c636 nSEG_NODE_653 0 84.9508f
c637 nSEG_NODE_654 0 95.18375f
c638 nSEG_NODE_655 0 58.36105f
c639 nSEG_NODE_656 0 57.6993f
c640 nSEG_NODE_657 0 57.6993f
c641 nSEG_NODE_658 0 53.1934f
c642 nSEG_NODE_659 0 89.801f
c643 nSEG_NODE_660 0 89.80075f
c644 nSEG_NODE_661 0 90.18025f
c645 nSEG_NODE_662 0 74.7094f
c646 nSEG_NODE_663 0 78.4219f
c647 nSEG_NODE_664 0 78.4219f
c648 nSEG_NODE_665 0 68.438f
c649 nSEG_NODE_666 0 68.437875f
c650 nSEG_NODE_667 0 63.575675f
c651 nSEG_NODE_668 0 94.5564f
c652 nSEG_NODE_669 0 94.5563f
c653 nSEG_NODE_670 0 76.3838f
c654 nSEG_NODE_671 0 76.38375f
c655 nSEG_NODE_672 0 66.62355f
c656 nSEG_NODE_673 0 66.62355f
c657 nSEG_NODE_674 0 75.3782f
c658 nSEG_NODE_675 0 75.37795f
c659 nSEG_NODE_676 0 85.4404f
c660 nSEG_NODE_677 0 85.4404f
c661 nSEG_NODE_678 0 85.44025f
c662 nSEG_NODE_679 0 69.6922f
c663 nSEG_NODE_680 0 69.6918f
c664 nSEG_NODE_681 0 56.8f
c665 nSEG_NODE_682 0 53.2086f
c666 nSEG_NODE_683 0 53.2086f
c667 nSEG_NODE_684 0 76.4462f
c668 nSEG_NODE_685 0 76.44615f
c669 nSEG_NODE_686 0 81.4604f
c670 nSEG_NODE_687 0 81.46015f
c671 nSEG_NODE_688 0 87.61495f
c672 nSEG_NODE_689 0 87.61495f
c673 nSEG_NODE_690 0 87.14725f
c674 nSEG_NODE_691 0 72.1064f
c675 nSEG_NODE_692 0 72.10625f
c676 nSEG_NODE_693 0 67.1172f
c677 nSEG_NODE_694 0 67.11685f
c678 nSEG_NODE_695 0 60.923f
c679 nSEG_NODE_696 0 83.1757f
c680 nSEG_NODE_697 0 58.8387f
c681 nSEG_NODE_698 0 65.7769f
c682 nSEG_NODE_699 0 58.62135f
c683 nSEG_NODE_700 0 58.62135f
c684 nSEG_NODE_701 0 65.55955f
c685 nSEG_NODE_702 0 94.9282f
c686 nSEG_NODE_703 0 94.9282f
c687 nSEG_NODE_704 0 94.92785f
c688 nSEG_NODE_705 0 67.8142f
c689 nSEG_NODE_706 0 67.814f
c690 nSEG_NODE_707 0 83.38335f
c691 nSEG_NODE_708 0 77.8339f
c692 nSEG_NODE_709 0 52.46615f
c693 nSEG_NODE_710 0 94.834f
c694 nSEG_NODE_711 0 55.674f
c695 nSEG_NODE_712 0 55.674f
c696 nSEG_NODE_713 0 53.15825f
c697 nSEG_NODE_714 0 53.15825f
r0 n358 n253 45.64245
r1 n359 n266 45.64245
r2 n362 n137 44.6396
r3 n365 n239 41.36855
r4 n366 n252 41.36855
r5 n369 n155 40.9401
r6 n381 n164 6.443725
r7 n384 n288 43.0143
r8 n385 n301 43.0143
r9 n386 n275 44.55055
r10 n387 n276 44.55055
r11 n395 n189 17.7653
r12 n397 n328 33.3769
r13 n403 n125 48.2054
r14 n404 n314 38.239
r15 n405 n315 38.239
r16 n407 n163 30.75135
r17 n410 n329 34.3407
r18 n411 n330 34.3407
r19 n413 n340 37.52485
r20 n415 n341 37.52485
r21 n416 n135 37.507
r22 n420 n191 49.0588
r23 n423 n326 42.61655
r24 n425 n327 42.61655
r25 n428 n158 27.12505
r26 n434 n312 39.94095
r27 n436 n313 39.94095
r28 n440 n260 30.1329
r29 n447 n153 40.10975
r30 n448 n273 48.3675
r31 n449 n274 48.3675
r32 n450 n286 34.8985
r33 n451 n287 34.8985
r34 n454 n145 7.67315
r35 n456 n131 39.042
r36 n458 n235 38.62155
r37 n460 n248 38.62155
r38 n462 n185 44.83965
r39 n464 n183 43.0884
r40 n468 n250 38.2545
r41 n470 n263 38.2545
r42 n472 n251 42.4695
r43 n474 n264 42.4695
r44 n479 n129 41.69745
r45 n480 n249 39.0062
r46 n481 n262 39.0062
r47 n482 n172 37.82705
r48 n483 n192 48.30135
r49 n492 n157 28.2667
r50 n501 n171 35.31465
r51 n503 n168 45.9135
r52 n506 n332 45.25175
r53 n507 n345 45.25175
r54 n509 n318 43.7437
r55 n511 n319 43.7437
r56 n513 n148 43.4177
r57 n515 n346 44.86115
r58 n517 n347 44.86115
r59 n519 n333 35.08545
r60 n521 n334 35.08545
r61 n522 n126 42.27555
r62 n526 n117 47.09
r63 n527 n136 40.86765
r64 n528 n279 39.69165
r65 n529 n280 39.69165
r66 n530 n292 33.4693
r67 n531 n293 33.4693
r68 n533 n306 36.0383
r69 n535 n307 36.0383
r70 n536 n281 36.7844
r71 n537 n294 36.7844
r72 n539 n198 14.558825
r73 n554 n308 39.3647
r74 n556 n309 39.3647
r75 n557 n146 22.92065
r76 n561 n298 46.7243
r77 n562 n311 46.7243
r78 n566 n337 47.7379
r79 n568 n350 47.7379
r80 n570 n323 43.7104
r81 n572 n324 43.7104
r82 n580 n304 41.20465
r83 n582 n317 41.20465
r84 n584 n278 9.83655
r85 n588 n221 45.31595
r86 n594 n269 48.70655
r87 n595 n270 48.70655
r88 n596 n127 43.768
r89 n597 n139 30.3964
r90 n599 n282 40.56285
r91 n601 n295 40.56285
r92 n603 n283 27.19125
r93 n605 n296 27.19125
r94 n611 n119 29.7809
r95 n613 n284 35.77865
r96 n615 n285 35.77865
r97 n623 n242 42.36785
r98 n625 n255 42.36785
r99 n626 n132 49.16975
r100 n627 n162 33.61055
r101 n633 n243 40.1148
r102 n635 n244 40.1148
r103 n636 n161 31.3747
r104 n637 n121 47.39575
r105 n638 n245 37.1372
r106 n639 n258 37.1372
r107 n351 nSEG_NODE_525 47.9242
r108 nSEG_NODE_525 nSEG_NODE_526 47.9242
r109 nSEG_NODE_526 nSEG_NODE_527 47.9242
r110 nSEG_NODE_527 nSEG_NODE_528 47.9242
r111 nSEG_NODE_528 nSEG_NODE_529 47.9242
r112 nSEG_NODE_529 nSEG_NODE_530 47.9242
r113 nSEG_NODE_530 nSEG_NODE_531 47.9242
r114 nSEG_NODE_531 nSEG_NODE_532 47.9242
r115 nSEG_NODE_532 nSEG_NODE_533 47.9242
r116 nSEG_NODE_533 nSEG_NODE_534 47.9242
r117 nSEG_NODE_534 nSEG_NODE_535 47.9242
r118 nSEG_NODE_535 nSEG_NODE_536 47.9242
r119 nSEG_NODE_536 nSEG_NODE_537 47.9242
r120 nSEG_NODE_537 nSEG_NODE_538 47.9242
r121 nSEG_NODE_538 nSEG_NODE_539 47.9242
r122 nSEG_NODE_539 nSEG_NODE_540 47.9242
r123 nSEG_NODE_540 n232 47.922025
r124 n353 nSEG_NODE_541 41.7591
r125 nSEG_NODE_541 n160 41.758975
r126 n354 nSEG_NODE_542 37.2602
r127 nSEG_NODE_542 n240 37.26015
r128 n357 nSEG_NODE_543 27.5241
r129 nSEG_NODE_543 n150 27.5241
r130 n360 nSEG_NODE_544 41.2399
r131 nSEG_NODE_544 n180 41.2399
r132 n361 nSEG_NODE_545 44.046
r133 nSEG_NODE_545 n199 44.0459
r134 n364 nSEG_NODE_546 43.0041
r135 nSEG_NODE_546 n265 43.00405
r136 n368 nSEG_NODE_547 45.8102
r137 nSEG_NODE_547 n241 45.81005
r138 n370 nSEG_NODE_548 25.3401
r139 nSEG_NODE_548 n254 25.34005
r140 n371 nSEG_NODE_549 25.3401
r141 nSEG_NODE_549 n267 25.34005
r142 n372 nSEG_NODE_550 46.135
r143 nSEG_NODE_550 nSEG_NODE_551 46.135
r144 nSEG_NODE_551 nSEG_NODE_552 46.135
r145 nSEG_NODE_552 nSEG_NODE_553 46.135
r146 nSEG_NODE_553 nSEG_NODE_554 46.135
r147 nSEG_NODE_554 nSEG_NODE_555 46.135
r148 nSEG_NODE_555 nSEG_NODE_556 46.135
r149 nSEG_NODE_556 nSEG_NODE_557 46.135
r150 nSEG_NODE_557 n223 46.134175
r151 n373 nSEG_NODE_558 45.9078
r152 nSEG_NODE_558 nSEG_NODE_559 45.9078
r153 nSEG_NODE_559 nSEG_NODE_560 45.9078
r154 nSEG_NODE_560 nSEG_NODE_561 45.9078
r155 nSEG_NODE_561 n188 45.907325
r156 n374 nSEG_NODE_562 33.7675
r157 nSEG_NODE_562 n227 33.76745
r158 n376 nSEG_NODE_563 27.3319
r159 nSEG_NODE_563 n305 27.33175
r160 n378 nSEG_NODE_564 44.9002
r161 nSEG_NODE_564 nSEG_NODE_565 44.9002
r162 nSEG_NODE_565 nSEG_NODE_566 44.9002
r163 nSEG_NODE_566 nSEG_NODE_567 44.9002
r164 nSEG_NODE_567 nSEG_NODE_568 44.9002
r165 nSEG_NODE_568 nSEG_NODE_569 44.9002
r166 nSEG_NODE_569 nSEG_NODE_570 44.9002
r167 nSEG_NODE_570 nSEG_NODE_571 44.9002
r168 nSEG_NODE_571 n229 44.89915
r169 n379 nSEG_NODE_572 49.804
r170 nSEG_NODE_572 nSEG_NODE_573 49.804
r171 nSEG_NODE_573 nSEG_NODE_574 49.804
r172 nSEG_NODE_574 nSEG_NODE_575 49.804
r173 nSEG_NODE_575 nSEG_NODE_576 49.804
r174 nSEG_NODE_576 nSEG_NODE_577 49.804
r175 nSEG_NODE_577 n230 49.803425
r176 n382 nSEG_NODE_578 41.2372
r177 nSEG_NODE_578 n147 41.23705
r178 n383 nSEG_NODE_579 42.0053
r179 nSEG_NODE_579 n138 42.0052
r180 n388 nSEG_NODE_580 48.6548
r181 nSEG_NODE_580 nSEG_NODE_581 48.6548
r182 nSEG_NODE_581 n194 48.654725
r183 n390 nSEG_NODE_582 42.214
r184 nSEG_NODE_582 nSEG_NODE_583 42.214
r185 nSEG_NODE_583 nSEG_NODE_584 42.214
r186 nSEG_NODE_584 nSEG_NODE_585 42.214
r187 nSEG_NODE_585 n226 42.213675
r188 n391 nSEG_NODE_586 43.0162
r189 nSEG_NODE_586 nSEG_NODE_587 43.0162
r190 nSEG_NODE_587 nSEG_NODE_588 43.0162
r191 nSEG_NODE_588 nSEG_NODE_589 43.0162
r192 nSEG_NODE_589 n195 43.01555
r193 n392 nSEG_NODE_590 42.7688
r194 nSEG_NODE_590 nSEG_NODE_591 42.7688
r195 nSEG_NODE_591 nSEG_NODE_592 42.7688
r196 nSEG_NODE_592 n213 42.768575
r197 n393 nSEG_NODE_593 39.8476
r198 nSEG_NODE_593 nSEG_NODE_594 39.8476
r199 nSEG_NODE_594 nSEG_NODE_595 39.8476
r200 nSEG_NODE_595 n225 39.847175
r201 n394 nSEG_NODE_596 34.8488
r202 nSEG_NODE_596 nSEG_NODE_597 34.8488
r203 nSEG_NODE_597 n124 34.84855
r204 n399 nSEG_NODE_598 43.4358
r205 nSEG_NODE_598 nSEG_NODE_599 43.4358
r206 nSEG_NODE_599 n167 43.4356
r207 n400 nSEG_NODE_600 42.9301
r208 nSEG_NODE_600 nSEG_NODE_601 42.9301
r209 nSEG_NODE_601 n222 42.9299
r210 n402 nSEG_NODE_602 43.2223
r211 nSEG_NODE_602 n316 43.2221
r212 n406 nSEG_NODE_603 25.2934
r213 nSEG_NODE_603 n122 25.2932
r214 n408 nSEG_NODE_604 27.088
r215 nSEG_NODE_604 n342 27.08795
r216 n409 nSEG_NODE_605 27.088
r217 nSEG_NODE_605 n343 27.08795
r218 n418 nSEG_NODE_606 41.971
r219 nSEG_NODE_606 nSEG_NODE_607 41.971
r220 nSEG_NODE_607 n165 41.97075
r221 n419 nSEG_NODE_608 27.3883
r222 nSEG_NODE_608 n208 27.3883
r223 n421 nSEG_NODE_609 42.9655
r224 nSEG_NODE_609 n143 42.9654
r225 n427 nSEG_NODE_610 39.7444
r226 nSEG_NODE_610 n325 39.74425
r227 n429 nSEG_NODE_611 26.1819
r228 nSEG_NODE_611 n338 26.1817
r229 n430 nSEG_NODE_612 26.1818
r230 nSEG_NODE_612 n339 26.1818
r231 n431 nSEG_NODE_613 28.7057
r232 nSEG_NODE_613 n299 28.7056
r233 n432 nSEG_NODE_614 28.7057
r234 nSEG_NODE_614 n300 28.7056
r235 n437 nSEG_NODE_615 40.6305
r236 nSEG_NODE_615 nSEG_NODE_616 40.6305
r237 nSEG_NODE_616 n207 40.63015
r238 n438 nSEG_NODE_617 46.1821
r239 nSEG_NODE_617 nSEG_NODE_618 46.1821
r240 nSEG_NODE_618 nSEG_NODE_619 46.1821
r241 nSEG_NODE_619 n176 46.18205
r242 n442 nSEG_NODE_620 27.0202
r243 nSEG_NODE_620 n261 27.02
r244 n444 nSEG_NODE_621 42.0058
r245 nSEG_NODE_621 nSEG_NODE_622 42.0058
r246 nSEG_NODE_622 n186 42.0054
r247 n445 nSEG_NODE_623 40.9589
r248 nSEG_NODE_623 nSEG_NODE_624 40.9589
r249 nSEG_NODE_624 n154 40.95865
r250 n446 nSEG_NODE_625 26.7894
r251 nSEG_NODE_625 n120 26.78935
r252 n453 nSEG_NODE_626 42.6684
r253 nSEG_NODE_626 n234 42.6683
r254 n455 nSEG_NODE_627 38.8319
r255 nSEG_NODE_627 n247 38.83165
r256 n461 nSEG_NODE_628 34.2924
r257 nSEG_NODE_628 nSEG_NODE_629 34.2924
r258 nSEG_NODE_629 n184 34.29205
r259 n463 nSEG_NODE_630 39.1418
r260 nSEG_NODE_630 n177 39.14165
r261 n465 nSEG_NODE_631 26.5915
r262 nSEG_NODE_631 n151 26.59145
r263 n466 nSEG_NODE_632 28.6991
r264 nSEG_NODE_632 n128 28.69885
r265 n475 nSEG_NODE_633 30.2287
r266 nSEG_NODE_633 n237 30.2287
r267 n476 nSEG_NODE_634 30.2287
r268 nSEG_NODE_634 n238 30.2287
r269 n478 nSEG_NODE_635 40.3519
r270 nSEG_NODE_635 n236 40.35175
r271 n485 nSEG_NODE_636 25.825
r272 nSEG_NODE_636 n289 25.8249
r273 n487 nSEG_NODE_637 25.825
r274 nSEG_NODE_637 n290 25.8249
r275 n489 nSEG_NODE_638 31.0621
r276 nSEG_NODE_638 n302 31.0621
r277 n491 nSEG_NODE_639 31.0622
r278 nSEG_NODE_639 n303 31.062
r279 n494 nSEG_NODE_640 45.651
r280 nSEG_NODE_640 nSEG_NODE_641 45.651
r281 nSEG_NODE_641 nSEG_NODE_642 45.651
r282 nSEG_NODE_642 nSEG_NODE_643 45.651
r283 nSEG_NODE_643 n219 45.650875
r284 n495 nSEG_NODE_644 42.1853
r285 nSEG_NODE_644 n187 42.1853
r286 n496 nSEG_NODE_645 44.75
r287 nSEG_NODE_645 nSEG_NODE_646 44.75
r288 nSEG_NODE_646 nSEG_NODE_647 44.75
r289 nSEG_NODE_647 nSEG_NODE_648 44.75
r290 nSEG_NODE_648 n210 44.74955
r291 n497 nSEG_NODE_649 41.5904
r292 nSEG_NODE_649 nSEG_NODE_650 41.5904
r293 nSEG_NODE_650 n220 41.59025
r294 n498 nSEG_NODE_651 45.1999
r295 nSEG_NODE_651 nSEG_NODE_652 45.1999
r296 nSEG_NODE_652 n156 45.1996
r297 n499 nSEG_NODE_653 42.4754
r298 nSEG_NODE_653 n203 42.4754
r299 n500 nSEG_NODE_654 47.5919
r300 nSEG_NODE_654 n142 47.59185
r301 n502 nSEG_NODE_655 29.1806
r302 nSEG_NODE_655 n149 29.18045
r303 n504 nSEG_NODE_656 28.8497
r304 nSEG_NODE_656 n331 28.8496
r305 n505 nSEG_NODE_657 28.8497
r306 nSEG_NODE_657 n344 28.8496
r307 n512 nSEG_NODE_658 26.5968
r308 nSEG_NODE_658 n118 26.5966
r309 n524 nSEG_NODE_659 44.9005
r310 nSEG_NODE_659 nSEG_NODE_660 44.9005
r311 nSEG_NODE_660 n123 44.90025
r312 n525 nSEG_NODE_661 45.0902
r313 nSEG_NODE_661 n144 45.09005
r314 n541 nSEG_NODE_662 37.3547
r315 nSEG_NODE_662 n310 37.3547
r316 n543 nSEG_NODE_663 39.211
r317 nSEG_NODE_663 n322 39.2109
r318 n544 nSEG_NODE_664 39.211
r319 nSEG_NODE_664 n336 39.2109
r320 n545 nSEG_NODE_665 34.219
r321 nSEG_NODE_665 nSEG_NODE_666 34.219
r322 nSEG_NODE_666 n214 34.218875
r323 n546 nSEG_NODE_667 31.7879
r324 nSEG_NODE_667 n204 31.787775
r325 n547 nSEG_NODE_668 47.2782
r326 nSEG_NODE_668 nSEG_NODE_669 47.2782
r327 nSEG_NODE_669 n130 47.2781
r328 n548 nSEG_NODE_670 38.1919
r329 nSEG_NODE_670 nSEG_NODE_671 38.1919
r330 nSEG_NODE_671 n178 38.19185
r331 n550 nSEG_NODE_672 33.3118
r332 nSEG_NODE_672 n335 33.31175
r333 n552 nSEG_NODE_673 33.3118
r334 nSEG_NODE_673 n348 33.31175
r335 n559 nSEG_NODE_674 37.6891
r336 nSEG_NODE_674 nSEG_NODE_675 37.6891
r337 nSEG_NODE_675 n182 37.68885
r338 n560 nSEG_NODE_676 42.7202
r339 nSEG_NODE_676 nSEG_NODE_677 42.7202
r340 nSEG_NODE_677 nSEG_NODE_678 42.7202
r341 nSEG_NODE_678 n159 42.72005
r342 n563 nSEG_NODE_679 34.8461
r343 nSEG_NODE_679 nSEG_NODE_680 34.8461
r344 nSEG_NODE_680 n349 34.8457
r345 n564 nSEG_NODE_681 28.4
r346 nSEG_NODE_681 n169 28.4
r347 n574 nSEG_NODE_682 26.6044
r348 nSEG_NODE_682 n320 26.6042
r349 n576 nSEG_NODE_683 26.6044
r350 nSEG_NODE_683 n321 26.6042
r351 n577 nSEG_NODE_684 38.2231
r352 nSEG_NODE_684 nSEG_NODE_685 38.2231
r353 nSEG_NODE_685 n134 38.22305
r354 n578 nSEG_NODE_686 40.7302
r355 nSEG_NODE_686 nSEG_NODE_687 40.7302
r356 nSEG_NODE_687 n133 40.72995
r357 n586 nSEG_NODE_688 43.8075
r358 nSEG_NODE_688 n291 43.80745
r359 n587 nSEG_NODE_689 43.8076
r360 nSEG_NODE_689 n277 43.80735
r361 n589 nSEG_NODE_690 43.5737
r362 nSEG_NODE_690 n205 43.57355
r363 n590 nSEG_NODE_691 36.0532
r364 nSEG_NODE_691 nSEG_NODE_692 36.0532
r365 nSEG_NODE_692 n181 36.05305
r366 n591 nSEG_NODE_693 33.5586
r367 nSEG_NODE_693 nSEG_NODE_694 33.5586
r368 nSEG_NODE_694 n196 33.55825
r369 n592 nSEG_NODE_695 30.4616
r370 nSEG_NODE_695 n140 30.4614
r371 n593 nSEG_NODE_696 41.5879
r372 nSEG_NODE_696 n152 41.5878
r373 n606 nSEG_NODE_697 29.4194
r374 nSEG_NODE_697 n173 29.4193
r375 n607 nSEG_NODE_698 32.8886
r376 nSEG_NODE_698 n174 32.8883
r377 n608 nSEG_NODE_699 29.3107
r378 nSEG_NODE_699 n271 29.31065
r379 n609 nSEG_NODE_700 29.3107
r380 nSEG_NODE_700 n272 29.31065
r381 n610 nSEG_NODE_701 32.7798
r382 nSEG_NODE_701 n297 32.77975
r383 n616 nSEG_NODE_702 47.4641
r384 nSEG_NODE_702 nSEG_NODE_703 47.4641
r385 nSEG_NODE_703 nSEG_NODE_704 47.4641
r386 nSEG_NODE_704 n179 47.46375
r387 n617 nSEG_NODE_705 33.9071
r388 nSEG_NODE_705 nSEG_NODE_706 33.9071
r389 nSEG_NODE_706 n218 33.9069
r390 n618 nSEG_NODE_707 41.6918
r391 nSEG_NODE_707 n166 41.69155
r392 n619 nSEG_NODE_708 38.917
r393 nSEG_NODE_708 n216 38.9169
r394 n620 nSEG_NODE_709 26.2331
r395 nSEG_NODE_709 n141 26.23305
r396 n621 nSEG_NODE_710 47.4171
r397 nSEG_NODE_710 n268 47.4169
r398 n629 nSEG_NODE_711 27.8371
r399 nSEG_NODE_711 n256 27.8369
r400 n631 nSEG_NODE_712 27.837
r401 nSEG_NODE_712 n257 27.837
r402 n640 nSEG_NODE_713 26.5792
r403 nSEG_NODE_713 n246 26.57905
r404 n641 nSEG_NODE_714 26.5792
r405 nSEG_NODE_714 n259 26.57905
x0 gin n0 vdd inv0
x1 n0 n351 vdd inv0
x2 n232 n224 vdd inv0
x3 n232 n353 vdd inv0
x4 n160 n354 vdd inv0
x5 n160 n201 vdd inv0
x6 n201 n197 vdd inv0
x7 n201 n357 vdd inv0
x8 n150 n358 vdd inv0
x9 n150 n359 vdd inv0
x10 n197 n360 vdd inv0
x11 n197 n361 vdd inv0
x12 n199 n362 vdd inv0
x13 n199 n363 vdd inv0
x14 n363 n364 vdd inv0
x15 n137 n365 vdd inv0
x16 n137 n366 vdd inv0
x17 n180 n367 vdd inv0
x18 n367 n368 vdd inv0
x19 n180 n369 vdd inv0
x20 n155 n370 vdd inv0
x21 n155 n371 vdd inv0
x22 n224 n372 vdd inv0
x23 n224 n373 vdd inv0
x24 n188 n374 vdd inv0
x25 n188 n231 vdd inv0
x26 n231 n376 vdd inv0
x27 n231 n217 vdd inv0
x28 n217 n378 vdd inv0
x29 n217 n379 vdd inv0
x30 n230 n175 vdd inv0
x31 n230 n381 vdd inv0
x32 n164 n382 vdd inv0
x33 n164 n383 vdd inv0
x34 n138 n384 vdd inv0
x35 n138 n385 vdd inv0
x36 n147 n386 vdd inv0
x37 n147 n387 vdd inv0
x38 n175 n388 vdd inv0
x39 n175 n215 vdd inv0
x40 n215 n390 vdd inv0
x41 n215 n391 vdd inv0
x42 n195 n392 vdd inv0
x43 n195 n393 vdd inv0
x44 n225 n394 vdd inv0
x45 n225 n395 vdd inv0
x46 n189 n396 vdd inv0
x47 n396 n397 vdd inv0
x48 n189 n209 vdd inv0
x49 n209 n399 vdd inv0
x50 n209 n400 vdd inv0
x51 n222 n401 vdd inv0
x52 n401 n402 vdd inv0
x53 n222 n403 vdd inv0
x54 n125 n404 vdd inv0
x55 n125 n405 vdd inv0
x56 n167 n406 vdd inv0
x57 n167 n407 vdd inv0
x58 n163 n408 vdd inv0
x59 n163 n409 vdd inv0
x60 n122 n410 vdd inv0
x61 n122 n411 vdd inv0
x62 n124 n412 vdd inv0
x63 n412 n413 vdd inv0
x64 n124 n414 vdd inv0
x65 n414 n415 vdd inv0
x66 n213 n416 vdd inv0
x67 n213 n212 vdd inv0
x68 n212 n418 vdd inv0
x69 n212 n419 vdd inv0
x70 n208 n420 vdd inv0
x71 n208 n421 vdd inv0
x72 n143 n422 vdd inv0
x73 n422 n423 vdd inv0
x74 n143 n424 vdd inv0
x75 n424 n425 vdd inv0
x76 n191 n426 vdd inv0
x77 n426 n427 vdd inv0
x78 n191 n428 vdd inv0
x79 n158 n429 vdd inv0
x80 n158 n430 vdd inv0
x81 n165 n431 vdd inv0
x82 n165 n432 vdd inv0
x83 n135 n433 vdd inv0
x84 n433 n434 vdd inv0
x85 n135 n435 vdd inv0
x86 n435 n436 vdd inv0
x87 n226 n437 vdd inv0
x88 n226 n438 vdd inv0
x89 n176 n206 vdd inv0
x90 n176 n440 vdd inv0
x91 n206 n441 vdd inv0
x92 n441 n442 vdd inv0
x93 n206 n202 vdd inv0
x94 n202 n444 vdd inv0
x95 n202 n445 vdd inv0
x96 n154 n446 vdd inv0
x97 n154 n447 vdd inv0
x98 n153 n448 vdd inv0
x99 n153 n449 vdd inv0
x100 n120 n450 vdd inv0
x101 n120 n451 vdd inv0
x102 n186 n452 vdd inv0
x103 n452 n453 vdd inv0
x104 n186 n454 vdd inv0
x105 n145 n455 vdd inv0
x106 n145 n456 vdd inv0
x107 n131 n457 vdd inv0
x108 n457 n458 vdd inv0
x109 n131 n459 vdd inv0
x110 n459 n460 vdd inv0
x111 n207 n461 vdd inv0
x112 n207 n462 vdd inv0
x113 n185 n463 vdd inv0
x114 n185 n464 vdd inv0
x115 n183 n465 vdd inv0
x116 n183 n466 vdd inv0
x117 n128 n467 vdd inv0
x118 n467 n468 vdd inv0
x119 n128 n469 vdd inv0
x120 n469 n470 vdd inv0
x121 n151 n471 vdd inv0
x122 n471 n472 vdd inv0
x123 n151 n473 vdd inv0
x124 n473 n474 vdd inv0
x125 n177 n475 vdd inv0
x126 n177 n476 vdd inv0
x127 n184 n477 vdd inv0
x128 n477 n478 vdd inv0
x129 n184 n479 vdd inv0
x130 n129 n480 vdd inv0
x131 n129 n481 vdd inv0
x132 n194 n482 vdd inv0
x133 n194 n483 vdd inv0
x134 n192 n484 vdd inv0
x135 n484 n485 vdd inv0
x136 n192 n486 vdd inv0
x137 n486 n487 vdd inv0
x138 n172 n488 vdd inv0
x139 n488 n489 vdd inv0
x140 n172 n490 vdd inv0
x141 n490 n491 vdd inv0
x142 n229 n492 vdd inv0
x143 n229 n228 vdd inv0
x144 n228 n494 vdd inv0
x145 n228 n495 vdd inv0
x146 n187 n496 vdd inv0
x147 n187 n497 vdd inv0
x148 n220 n498 vdd inv0
x149 n220 n499 vdd inv0
x150 n203 n500 vdd inv0
x151 n203 n501 vdd inv0
x152 n171 n502 vdd inv0
x153 n171 n503 vdd inv0
x154 n168 n504 vdd inv0
x155 n168 n505 vdd inv0
x156 n149 n506 vdd inv0
x157 n149 n507 vdd inv0
x158 n142 n508 vdd inv0
x159 n508 n509 vdd inv0
x160 n142 n510 vdd inv0
x161 n510 n511 vdd inv0
x162 n156 n512 vdd inv0
x163 n156 n513 vdd inv0
x164 n148 n514 vdd inv0
x165 n514 n515 vdd inv0
x166 n148 n516 vdd inv0
x167 n516 n517 vdd inv0
x168 n118 n518 vdd inv0
x169 n518 n519 vdd inv0
x170 n118 n520 vdd inv0
x171 n520 n521 vdd inv0
x172 n210 n522 vdd inv0
x173 n210 n190 vdd inv0
x174 n190 n524 vdd inv0
x175 n190 n525 vdd inv0
x176 n144 n526 vdd inv0
x177 n144 n527 vdd inv0
x178 n136 n528 vdd inv0
x179 n136 n529 vdd inv0
x180 n117 n530 vdd inv0
x181 n117 n531 vdd inv0
x182 n123 n532 vdd inv0
x183 n532 n533 vdd inv0
x184 n123 n534 vdd inv0
x185 n534 n535 vdd inv0
x186 n126 n536 vdd inv0
x187 n126 n537 vdd inv0
x188 n219 n200 vdd inv0
x189 n219 n539 vdd inv0
x190 n198 n540 vdd inv0
x191 n540 n541 vdd inv0
x192 n198 n170 vdd inv0
x193 n170 n543 vdd inv0
x194 n170 n544 vdd inv0
x195 n200 n545 vdd inv0
x196 n200 n546 vdd inv0
x197 n204 n547 vdd inv0
x198 n204 n548 vdd inv0
x199 n178 n549 vdd inv0
x200 n549 n550 vdd inv0
x201 n178 n551 vdd inv0
x202 n551 n552 vdd inv0
x203 n130 n553 vdd inv0
x204 n553 n554 vdd inv0
x205 n130 n555 vdd inv0
x206 n555 n556 vdd inv0
x207 n214 n557 vdd inv0
x208 n214 n211 vdd inv0
x209 n211 n559 vdd inv0
x210 n211 n560 vdd inv0
x211 n159 n561 vdd inv0
x212 n159 n562 vdd inv0
x213 n182 n563 vdd inv0
x214 n182 n564 vdd inv0
x215 n169 n565 vdd inv0
x216 n565 n566 vdd inv0
x217 n169 n567 vdd inv0
x218 n567 n568 vdd inv0
x219 n146 n569 vdd inv0
x220 n569 n570 vdd inv0
x221 n146 n571 vdd inv0
x222 n571 n572 vdd inv0
x223 n157 n573 vdd inv0
x224 n573 n574 vdd inv0
x225 n157 n575 vdd inv0
x226 n575 n576 vdd inv0
x227 n227 n577 vdd inv0
x228 n227 n578 vdd inv0
x229 n133 n579 vdd inv0
x230 n579 n580 vdd inv0
x231 n133 n581 vdd inv0
x232 n581 n582 vdd inv0
x233 n134 n583 vdd inv0
x234 n583 n584 vdd inv0
x235 n134 n193 vdd inv0
x236 n193 n586 vdd inv0
x237 n193 n587 vdd inv0
x238 n223 n588 vdd inv0
x239 n223 n589 vdd inv0
x240 n205 n590 vdd inv0
x241 n205 n591 vdd inv0
x242 n196 n592 vdd inv0
x243 n196 n593 vdd inv0
x244 n152 n594 vdd inv0
x245 n152 n595 vdd inv0
x246 n140 n596 vdd inv0
x247 n140 n597 vdd inv0
x248 n139 n598 vdd inv0
x249 n598 n599 vdd inv0
x250 n139 n600 vdd inv0
x251 n600 n601 vdd inv0
x252 n127 n602 vdd inv0
x253 n602 n603 vdd inv0
x254 n127 n604 vdd inv0
x255 n604 n605 vdd inv0
x256 n181 n606 vdd inv0
x257 n181 n607 vdd inv0
x258 n174 n608 vdd inv0
x259 n174 n609 vdd inv0
x260 n173 n610 vdd inv0
x261 n173 n611 vdd inv0
x262 n119 n612 vdd inv0
x263 n612 n613 vdd inv0
x264 n119 n614 vdd inv0
x265 n614 n615 vdd inv0
x266 n221 n616 vdd inv0
x267 n221 n617 vdd inv0
x268 n218 n618 vdd inv0
x269 n218 n619 vdd inv0
x270 n216 n620 vdd inv0
x271 n216 n621 vdd inv0
x272 n141 n622 vdd inv0
x273 n622 n623 vdd inv0
x274 n141 n624 vdd inv0
x275 n624 n625 vdd inv0
x276 n166 n626 vdd inv0
x277 n166 n627 vdd inv0
x278 n162 n628 vdd inv0
x279 n628 n629 vdd inv0
x280 n162 n630 vdd inv0
x281 n630 n631 vdd inv0
x282 n132 n632 vdd inv0
x283 n632 n633 vdd inv0
x284 n132 n634 vdd inv0
x285 n634 n635 vdd inv0
x286 n179 n636 vdd inv0
x287 n179 n637 vdd inv0
x288 n121 n638 vdd inv0
x289 n121 n639 vdd inv0
x290 n161 n640 vdd inv0
x291 n161 n641 vdd inv0
*
vdd vdd 0 1.2
vdt gin 0 1.2 pwl(0n 0, 0.2n 0, 0.325n 1.2, 2n 1.2)
*
.ic v(gin)=0
.ic v(n0)=1.2
.ic v(n117)=1.2
.ic v(n118)=0
.ic v(n119)=0
.ic v(n120)=1.2
.ic v(n121)=1.2
.ic v(n122)=1.2
.ic v(n123)=0
.ic v(n124)=0
.ic v(n125)=1.2
.ic v(n126)=1.2
.ic v(n127)=0
.ic v(n128)=0
.ic v(n129)=1.2
.ic v(n130)=0
.ic v(n131)=0
.ic v(n132)=0
.ic v(n133)=0
.ic v(n134)=0
.ic v(n135)=0
.ic v(n136)=1.2
.ic v(n137)=1.2
.ic v(n138)=1.2
.ic v(n139)=0
.ic v(n140)=1.2
.ic v(n141)=0
.ic v(n142)=0
.ic v(n143)=0
.ic v(n144)=0
.ic v(n145)=1.2
.ic v(n146)=0
.ic v(n147)=1.2
.ic v(n148)=0
.ic v(n149)=1.2
.ic v(n150)=1.2
.ic v(n151)=0
.ic v(n152)=1.2
.ic v(n153)=1.2
.ic v(n154)=0
.ic v(n155)=1.2
.ic v(n156)=1.2
.ic v(n157)=0
.ic v(n158)=1.2
.ic v(n159)=1.2
.ic v(n160)=1.2
.ic v(n161)=1.2
.ic v(n162)=0
.ic v(n163)=1.2
.ic v(n164)=0
.ic v(n165)=1.2
.ic v(n166)=1.2
.ic v(n167)=0
.ic v(n168)=1.2
.ic v(n169)=0
.ic v(n170)=1.2
.ic v(n171)=0
.ic v(n172)=0
.ic v(n173)=1.2
.ic v(n174)=1.2
.ic v(n175)=0
.ic v(n176)=1.2
.ic v(n177)=1.2
.ic v(n178)=0
.ic v(n179)=0
.ic v(n180)=0
.ic v(n181)=0
.ic v(n182)=1.2
.ic v(n183)=1.2
.ic v(n184)=0
.ic v(n185)=0
.ic v(n186)=0
.ic v(n187)=1.2
.ic v(n188)=0
.ic v(n189)=0
.ic v(n190)=1.2
.ic v(n191)=0
.ic v(n192)=0
.ic v(n193)=1.2
.ic v(n194)=1.2
.ic v(n195)=0
.ic v(n196)=0
.ic v(n197)=1.2
.ic v(n198)=0
.ic v(n199)=0
.ic v(n200)=0
.ic v(n201)=0
.ic v(n202)=1.2
.ic v(n203)=1.2
.ic v(n204)=1.2
.ic v(n205)=1.2
.ic v(n206)=0
.ic v(n207)=1.2
.ic v(n208)=1.2
.ic v(n209)=1.2
.ic v(n210)=0
.ic v(n211)=0
.ic v(n212)=0
.ic v(n213)=1.2
.ic v(n214)=1.2
.ic v(n215)=1.2
.ic v(n216)=1.2
.ic v(n217)=0
.ic v(n218)=0
.ic v(n219)=1.2
.ic v(n220)=0
.ic v(n221)=1.2
.ic v(n222)=0
.ic v(n223)=0
.ic v(n224)=1.2
.ic v(n225)=1.2
.ic v(n226)=0
.ic v(n227)=1.2
.ic v(n228)=0
.ic v(n229)=1.2
.ic v(n230)=1.2
.ic v(n231)=1.2
.ic v(n232)=0
.ic v(n351)=0
.ic v(n353)=1.2
.ic v(n354)=0
.ic v(n357)=1.2
.ic v(n358)=0
.ic v(n359)=0
.ic v(n360)=0
.ic v(n361)=0
.ic v(n362)=1.2
.ic v(n363)=1.2
.ic v(n364)=0
.ic v(n365)=0
.ic v(n366)=0
.ic v(n367)=1.2
.ic v(n368)=0
.ic v(n369)=1.2
.ic v(n370)=0
.ic v(n371)=0
.ic v(n372)=0
.ic v(n373)=0
.ic v(n374)=1.2
.ic v(n376)=0
.ic v(n378)=1.2
.ic v(n379)=1.2
.ic v(n381)=0
.ic v(n382)=1.2
.ic v(n383)=1.2
.ic v(n384)=0
.ic v(n385)=0
.ic v(n386)=0
.ic v(n387)=0
.ic v(n388)=1.2
.ic v(n390)=0
.ic v(n391)=0
.ic v(n392)=1.2
.ic v(n393)=1.2
.ic v(n394)=0
.ic v(n395)=0
.ic v(n396)=1.2
.ic v(n397)=0
.ic v(n399)=0
.ic v(n400)=0
.ic v(n401)=1.2
.ic v(n402)=0
.ic v(n403)=1.2
.ic v(n404)=0
.ic v(n405)=0
.ic v(n406)=1.2
.ic v(n407)=1.2
.ic v(n408)=0
.ic v(n409)=0
.ic v(n410)=0
.ic v(n411)=0
.ic v(n412)=1.2
.ic v(n413)=0
.ic v(n414)=1.2
.ic v(n415)=0
.ic v(n416)=0
.ic v(n418)=1.2
.ic v(n419)=1.2
.ic v(n420)=0
.ic v(n421)=0
.ic v(n422)=1.2
.ic v(n423)=0
.ic v(n424)=1.2
.ic v(n425)=0
.ic v(n426)=1.2
.ic v(n427)=0
.ic v(n428)=1.2
.ic v(n429)=0
.ic v(n430)=0
.ic v(n431)=0
.ic v(n432)=0
.ic v(n433)=1.2
.ic v(n434)=0
.ic v(n435)=1.2
.ic v(n436)=0
.ic v(n437)=1.2
.ic v(n438)=1.2
.ic v(n440)=0
.ic v(n441)=1.2
.ic v(n442)=0
.ic v(n444)=0
.ic v(n445)=0
.ic v(n446)=1.2
.ic v(n447)=1.2
.ic v(n448)=0
.ic v(n449)=0
.ic v(n450)=0
.ic v(n451)=0
.ic v(n452)=1.2
.ic v(n453)=0
.ic v(n454)=1.2
.ic v(n455)=0
.ic v(n456)=0
.ic v(n457)=1.2
.ic v(n458)=0
.ic v(n459)=1.2
.ic v(n460)=0
.ic v(n461)=0
.ic v(n462)=0
.ic v(n463)=1.2
.ic v(n464)=1.2
.ic v(n465)=0
.ic v(n466)=0
.ic v(n467)=1.2
.ic v(n468)=0
.ic v(n469)=1.2
.ic v(n470)=0
.ic v(n471)=1.2
.ic v(n472)=0
.ic v(n473)=1.2
.ic v(n474)=0
.ic v(n475)=0
.ic v(n476)=0
.ic v(n477)=1.2
.ic v(n478)=0
.ic v(n479)=1.2
.ic v(n480)=0
.ic v(n481)=0
.ic v(n482)=0
.ic v(n483)=0
.ic v(n484)=1.2
.ic v(n485)=0
.ic v(n486)=1.2
.ic v(n487)=0
.ic v(n488)=1.2
.ic v(n489)=0
.ic v(n490)=1.2
.ic v(n491)=0
.ic v(n492)=0
.ic v(n494)=1.2
.ic v(n495)=1.2
.ic v(n496)=0
.ic v(n497)=0
.ic v(n498)=1.2
.ic v(n499)=1.2
.ic v(n500)=0
.ic v(n501)=0
.ic v(n502)=1.2
.ic v(n503)=1.2
.ic v(n504)=0
.ic v(n505)=0
.ic v(n506)=0
.ic v(n507)=0
.ic v(n508)=1.2
.ic v(n509)=0
.ic v(n510)=1.2
.ic v(n511)=0
.ic v(n512)=0
.ic v(n513)=0
.ic v(n514)=1.2
.ic v(n515)=0
.ic v(n516)=1.2
.ic v(n517)=0
.ic v(n518)=1.2
.ic v(n519)=0
.ic v(n520)=1.2
.ic v(n521)=0
.ic v(n522)=1.2
.ic v(n524)=0
.ic v(n525)=0
.ic v(n526)=1.2
.ic v(n527)=1.2
.ic v(n528)=0
.ic v(n529)=0
.ic v(n530)=0
.ic v(n531)=0
.ic v(n532)=1.2
.ic v(n533)=0
.ic v(n534)=1.2
.ic v(n535)=0
.ic v(n536)=0
.ic v(n537)=0
.ic v(n539)=0
.ic v(n540)=1.2
.ic v(n541)=0
.ic v(n543)=0
.ic v(n544)=0
.ic v(n545)=1.2
.ic v(n546)=1.2
.ic v(n547)=0
.ic v(n548)=0
.ic v(n549)=1.2
.ic v(n550)=0
.ic v(n551)=1.2
.ic v(n552)=0
.ic v(n553)=1.2
.ic v(n554)=0
.ic v(n555)=1.2
.ic v(n556)=0
.ic v(n557)=0
.ic v(n559)=1.2
.ic v(n560)=1.2
.ic v(n561)=0
.ic v(n562)=0
.ic v(n563)=0
.ic v(n564)=0
.ic v(n565)=1.2
.ic v(n566)=0
.ic v(n567)=1.2
.ic v(n568)=0
.ic v(n569)=1.2
.ic v(n570)=0
.ic v(n571)=1.2
.ic v(n572)=0
.ic v(n573)=1.2
.ic v(n574)=0
.ic v(n575)=1.2
.ic v(n576)=0
.ic v(n577)=0
.ic v(n578)=0
.ic v(n579)=1.2
.ic v(n580)=0
.ic v(n581)=1.2
.ic v(n582)=0
.ic v(n583)=1.2
.ic v(n584)=0
.ic v(n586)=0
.ic v(n587)=0
.ic v(n588)=1.2
.ic v(n589)=1.2
.ic v(n590)=0
.ic v(n591)=0
.ic v(n592)=1.2
.ic v(n593)=1.2
.ic v(n594)=0
.ic v(n595)=0
.ic v(n596)=0
.ic v(n597)=0
.ic v(n598)=1.2
.ic v(n599)=0
.ic v(n600)=1.2
.ic v(n601)=0
.ic v(n602)=1.2
.ic v(n603)=0
.ic v(n604)=1.2
.ic v(n605)=0
.ic v(n606)=1.2
.ic v(n607)=1.2
.ic v(n608)=0
.ic v(n609)=0
.ic v(n610)=0
.ic v(n611)=0
.ic v(n612)=1.2
.ic v(n613)=0
.ic v(n614)=1.2
.ic v(n615)=0
.ic v(n616)=0
.ic v(n617)=0
.ic v(n618)=1.2
.ic v(n619)=1.2
.ic v(n620)=0
.ic v(n621)=0
.ic v(n622)=1.2
.ic v(n623)=0
.ic v(n624)=1.2
.ic v(n625)=0
.ic v(n626)=0
.ic v(n627)=0
.ic v(n628)=1.2
.ic v(n629)=0
.ic v(n630)=1.2
.ic v(n631)=0
.ic v(n632)=1.2
.ic v(n633)=0
.ic v(n634)=1.2
.ic v(n635)=0
.ic v(n636)=1.2
.ic v(n637)=1.2
.ic v(n638)=0
.ic v(n639)=0
.ic v(n640)=0
.ic v(n641)=0
.ic v(n234)=0
.ic v(n235)=0
.ic v(n236)=0
.ic v(n237)=0
.ic v(n238)=0
.ic v(n239)=0
.ic v(n240)=0
.ic v(n241)=0
.ic v(n242)=0
.ic v(n243)=0
.ic v(n244)=0
.ic v(n245)=0
.ic v(n246)=0
.ic v(n247)=0
.ic v(n248)=0
.ic v(n249)=0
.ic v(n250)=0
.ic v(n251)=0
.ic v(n252)=0
.ic v(n253)=0
.ic v(n254)=0
.ic v(n255)=0
.ic v(n256)=0
.ic v(n257)=0
.ic v(n258)=0
.ic v(n259)=0
.ic v(n260)=0
.ic v(n261)=0
.ic v(n262)=0
.ic v(n263)=0
.ic v(n264)=0
.ic v(n265)=0
.ic v(n266)=0
.ic v(n267)=0
.ic v(n268)=0
.ic v(n269)=0
.ic v(n270)=0
.ic v(n271)=0
.ic v(n272)=0
.ic v(n273)=0
.ic v(n274)=0
.ic v(n275)=0
.ic v(n276)=0
.ic v(n277)=0
.ic v(n278)=0
.ic v(n279)=0
.ic v(n280)=0
.ic v(n281)=0
.ic v(n282)=0
.ic v(n283)=0
.ic v(n284)=0
.ic v(n285)=0
.ic v(n286)=0
.ic v(n287)=0
.ic v(n288)=0
.ic v(n289)=0
.ic v(n290)=0
.ic v(n291)=0
.ic v(n292)=0
.ic v(n293)=0
.ic v(n294)=0
.ic v(n295)=0
.ic v(n296)=0
.ic v(n297)=0
.ic v(n298)=0
.ic v(n299)=0
.ic v(n300)=0
.ic v(n301)=0
.ic v(n302)=0
.ic v(n303)=0
.ic v(n304)=0
.ic v(n305)=0
.ic v(n306)=0
.ic v(n307)=0
.ic v(n308)=0
.ic v(n309)=0
.ic v(n310)=0
.ic v(n311)=0
.ic v(n312)=0
.ic v(n313)=0
.ic v(n314)=0
.ic v(n315)=0
.ic v(n316)=0
.ic v(n317)=0
.ic v(n318)=0
.ic v(n319)=0
.ic v(n320)=0
.ic v(n321)=0
.ic v(n322)=0
.ic v(n323)=0
.ic v(n324)=0
.ic v(n325)=0
.ic v(n326)=0
.ic v(n327)=0
.ic v(n328)=0
.ic v(n329)=0
.ic v(n330)=0
.ic v(n331)=0
.ic v(n332)=0
.ic v(n333)=0
.ic v(n334)=0
.ic v(n335)=0
.ic v(n336)=0
.ic v(n337)=0
.ic v(n338)=0
.ic v(n339)=0
.ic v(n340)=0
.ic v(n341)=0
.ic v(n342)=0
.ic v(n343)=0
.ic v(n344)=0
.ic v(n345)=0
.ic v(n346)=0
.ic v(n347)=0
.ic v(n348)=0
.ic v(n349)=0
.ic v(n350)=0
.ic v(nSEG_NODE_525)=1.2
.ic v(nSEG_NODE_526)=1.2
.ic v(nSEG_NODE_527)=1.2
.ic v(nSEG_NODE_528)=1.2
.ic v(nSEG_NODE_529)=1.2
.ic v(nSEG_NODE_530)=1.2
.ic v(nSEG_NODE_531)=1.2
.ic v(nSEG_NODE_532)=1.2
.ic v(nSEG_NODE_533)=1.2
.ic v(nSEG_NODE_534)=1.2
.ic v(nSEG_NODE_535)=1.2
.ic v(nSEG_NODE_536)=1.2
.ic v(nSEG_NODE_537)=1.2
.ic v(nSEG_NODE_538)=1.2
.ic v(nSEG_NODE_539)=1.2
.ic v(nSEG_NODE_540)=1.2
.ic v(nSEG_NODE_541)=1.2
.ic v(nSEG_NODE_542)=1.2
.ic v(nSEG_NODE_543)=1.2
.ic v(nSEG_NODE_544)=1.2
.ic v(nSEG_NODE_545)=1.2
.ic v(nSEG_NODE_546)=1.2
.ic v(nSEG_NODE_547)=1.2
.ic v(nSEG_NODE_548)=1.2
.ic v(nSEG_NODE_549)=1.2
.ic v(nSEG_NODE_550)=1.2
.ic v(nSEG_NODE_551)=1.2
.ic v(nSEG_NODE_552)=1.2
.ic v(nSEG_NODE_553)=1.2
.ic v(nSEG_NODE_554)=1.2
.ic v(nSEG_NODE_555)=1.2
.ic v(nSEG_NODE_556)=1.2
.ic v(nSEG_NODE_557)=1.2
.ic v(nSEG_NODE_558)=1.2
.ic v(nSEG_NODE_559)=1.2
.ic v(nSEG_NODE_560)=1.2
.ic v(nSEG_NODE_561)=1.2
.ic v(nSEG_NODE_562)=1.2
.ic v(nSEG_NODE_563)=1.2
.ic v(nSEG_NODE_564)=1.2
.ic v(nSEG_NODE_565)=1.2
.ic v(nSEG_NODE_566)=1.2
.ic v(nSEG_NODE_567)=1.2
.ic v(nSEG_NODE_568)=1.2
.ic v(nSEG_NODE_569)=1.2
.ic v(nSEG_NODE_570)=1.2
.ic v(nSEG_NODE_571)=1.2
.ic v(nSEG_NODE_572)=1.2
.ic v(nSEG_NODE_573)=1.2
.ic v(nSEG_NODE_574)=1.2
.ic v(nSEG_NODE_575)=1.2
.ic v(nSEG_NODE_576)=1.2
.ic v(nSEG_NODE_577)=1.2
.ic v(nSEG_NODE_578)=1.2
.ic v(nSEG_NODE_579)=1.2
.ic v(nSEG_NODE_580)=1.2
.ic v(nSEG_NODE_581)=1.2
.ic v(nSEG_NODE_582)=1.2
.ic v(nSEG_NODE_583)=1.2
.ic v(nSEG_NODE_584)=1.2
.ic v(nSEG_NODE_585)=1.2
.ic v(nSEG_NODE_586)=1.2
.ic v(nSEG_NODE_587)=1.2
.ic v(nSEG_NODE_588)=1.2
.ic v(nSEG_NODE_589)=1.2
.ic v(nSEG_NODE_590)=1.2
.ic v(nSEG_NODE_591)=1.2
.ic v(nSEG_NODE_592)=1.2
.ic v(nSEG_NODE_593)=1.2
.ic v(nSEG_NODE_594)=1.2
.ic v(nSEG_NODE_595)=1.2
.ic v(nSEG_NODE_596)=1.2
.ic v(nSEG_NODE_597)=1.2
.ic v(nSEG_NODE_598)=1.2
.ic v(nSEG_NODE_599)=1.2
.ic v(nSEG_NODE_600)=1.2
.ic v(nSEG_NODE_601)=1.2
.ic v(nSEG_NODE_602)=1.2
.ic v(nSEG_NODE_603)=1.2
.ic v(nSEG_NODE_604)=1.2
.ic v(nSEG_NODE_605)=1.2
.ic v(nSEG_NODE_606)=1.2
.ic v(nSEG_NODE_607)=1.2
.ic v(nSEG_NODE_608)=1.2
.ic v(nSEG_NODE_609)=1.2
.ic v(nSEG_NODE_610)=1.2
.ic v(nSEG_NODE_611)=1.2
.ic v(nSEG_NODE_612)=1.2
.ic v(nSEG_NODE_613)=1.2
.ic v(nSEG_NODE_614)=1.2
.ic v(nSEG_NODE_615)=1.2
.ic v(nSEG_NODE_616)=1.2
.ic v(nSEG_NODE_617)=1.2
.ic v(nSEG_NODE_618)=1.2
.ic v(nSEG_NODE_619)=1.2
.ic v(nSEG_NODE_620)=1.2
.ic v(nSEG_NODE_621)=1.2
.ic v(nSEG_NODE_622)=1.2
.ic v(nSEG_NODE_623)=1.2
.ic v(nSEG_NODE_624)=1.2
.ic v(nSEG_NODE_625)=1.2
.ic v(nSEG_NODE_626)=1.2
.ic v(nSEG_NODE_627)=1.2
.ic v(nSEG_NODE_628)=1.2
.ic v(nSEG_NODE_629)=1.2
.ic v(nSEG_NODE_630)=1.2
.ic v(nSEG_NODE_631)=1.2
.ic v(nSEG_NODE_632)=1.2
.ic v(nSEG_NODE_633)=1.2
.ic v(nSEG_NODE_634)=1.2
.ic v(nSEG_NODE_635)=1.2
.ic v(nSEG_NODE_636)=1.2
.ic v(nSEG_NODE_637)=1.2
.ic v(nSEG_NODE_638)=1.2
.ic v(nSEG_NODE_639)=1.2
.ic v(nSEG_NODE_640)=1.2
.ic v(nSEG_NODE_641)=1.2
.ic v(nSEG_NODE_642)=1.2
.ic v(nSEG_NODE_643)=1.2
.ic v(nSEG_NODE_644)=1.2
.ic v(nSEG_NODE_645)=1.2
.ic v(nSEG_NODE_646)=1.2
.ic v(nSEG_NODE_647)=1.2
.ic v(nSEG_NODE_648)=1.2
.ic v(nSEG_NODE_649)=1.2
.ic v(nSEG_NODE_650)=1.2
.ic v(nSEG_NODE_651)=1.2
.ic v(nSEG_NODE_652)=1.2
.ic v(nSEG_NODE_653)=1.2
.ic v(nSEG_NODE_654)=1.2
.ic v(nSEG_NODE_655)=1.2
.ic v(nSEG_NODE_656)=1.2
.ic v(nSEG_NODE_657)=1.2
.ic v(nSEG_NODE_658)=1.2
.ic v(nSEG_NODE_659)=1.2
.ic v(nSEG_NODE_660)=1.2
.ic v(nSEG_NODE_661)=1.2
.ic v(nSEG_NODE_662)=1.2
.ic v(nSEG_NODE_663)=1.2
.ic v(nSEG_NODE_664)=1.2
.ic v(nSEG_NODE_665)=1.2
.ic v(nSEG_NODE_666)=1.2
.ic v(nSEG_NODE_667)=1.2
.ic v(nSEG_NODE_668)=1.2
.ic v(nSEG_NODE_669)=1.2
.ic v(nSEG_NODE_670)=1.2
.ic v(nSEG_NODE_671)=1.2
.ic v(nSEG_NODE_672)=1.2
.ic v(nSEG_NODE_673)=1.2
.ic v(nSEG_NODE_674)=1.2
.ic v(nSEG_NODE_675)=1.2
.ic v(nSEG_NODE_676)=1.2
.ic v(nSEG_NODE_677)=1.2
.ic v(nSEG_NODE_678)=1.2
.ic v(nSEG_NODE_679)=1.2
.ic v(nSEG_NODE_680)=1.2
.ic v(nSEG_NODE_681)=1.2
.ic v(nSEG_NODE_682)=1.2
.ic v(nSEG_NODE_683)=1.2
.ic v(nSEG_NODE_684)=1.2
.ic v(nSEG_NODE_685)=1.2
.ic v(nSEG_NODE_686)=1.2
.ic v(nSEG_NODE_687)=1.2
.ic v(nSEG_NODE_688)=1.2
.ic v(nSEG_NODE_689)=1.2
.ic v(nSEG_NODE_690)=1.2
.ic v(nSEG_NODE_691)=1.2
.ic v(nSEG_NODE_692)=1.2
.ic v(nSEG_NODE_693)=1.2
.ic v(nSEG_NODE_694)=1.2
.ic v(nSEG_NODE_695)=1.2
.ic v(nSEG_NODE_696)=1.2
.ic v(nSEG_NODE_697)=1.2
.ic v(nSEG_NODE_698)=1.2
.ic v(nSEG_NODE_699)=1.2
.ic v(nSEG_NODE_700)=1.2
.ic v(nSEG_NODE_701)=1.2
.ic v(nSEG_NODE_702)=1.2
.ic v(nSEG_NODE_703)=1.2
.ic v(nSEG_NODE_704)=1.2
.ic v(nSEG_NODE_705)=1.2
.ic v(nSEG_NODE_706)=1.2
.ic v(nSEG_NODE_707)=1.2
.ic v(nSEG_NODE_708)=1.2
.ic v(nSEG_NODE_709)=1.2
.ic v(nSEG_NODE_710)=1.2
.ic v(nSEG_NODE_711)=1.2
.ic v(nSEG_NODE_712)=1.2
.ic v(nSEG_NODE_713)=1.2
.ic v(nSEG_NODE_714)=1.2
*
.opti nopage temp=75
.width out=240
*
.tran 0.01n 2n 0.0n 0.01n
* .print tran v(gin) v(n0) v(n232) v(n160) v(n201) v(n150) v(n197) v(n199) v(n363) v(n137) v(n180) v(n367) v(n155) v(n224) v(n188) v(n231) v(n217) v(n230) v(n164) v(n138) v(n147) v(n175) v(n215) v(n195) v(n225) v(n189) v(n396) v(n209) v(n222) v(n401) v(n125) v(n167) v(n163) v(n122) v(n124) v(n412) v(n414) v(n213) v(n212) v(n208) v(n143) v(n422) v(n424) v(n191) v(n426) v(n158) v(n165) v(n135) v(n433) v(n435) v(n226) v(n176) v(n206) v(n441) v(n202) v(n154) v(n153) v(n120) v(n186) v(n452) v(n145) v(n131) v(n457) v(n459) v(n207) v(n185) v(n183) v(n128) v(n467) v(n469) v(n151) v(n471) v(n473) v(n177) v(n184) v(n477) v(n129) v(n194) v(n192) v(n484) v(n486) v(n172) v(n488) v(n490) v(n229) v(n228) v(n187) v(n220) v(n203) v(n171) v(n168) v(n149) v(n142) v(n508) v(n510) v(n156) v(n148) v(n514) v(n516) v(n118) v(n518) v(n520) v(n210) v(n190) v(n144) v(n136) v(n117) v(n123) v(n532) v(n534) v(n126) v(n219) v(n198) v(n540) v(n170) v(n200) v(n204) v(n178) v(n549) v(n551) v(n130) v(n553) v(n555) v(n214) v(n211) v(n159) v(n182) v(n169) v(n565) v(n567) v(n146) v(n569) v(n571) v(n157) v(n573) v(n575) v(n227) v(n133) v(n579) v(n581) v(n134) v(n583) v(n193) v(n223) v(n205) v(n196) v(n152) v(n140) v(n139) v(n598) v(n600) v(n127) v(n602) v(n604) v(n181) v(n174) v(n173) v(n119) v(n612) v(n614) v(n221) v(n218) v(n216) v(n141) v(n622) v(n624) v(n166) v(n162) v(n628) v(n630) v(n132) v(n632) v(n634) v(n179) v(n121) v(n161) v(n234) v(n235) v(n236) v(n237) v(n238) v(n239) v(n240) v(n241) v(n242) v(n446) v(n244) v(n245) v(n246) v(n247) v(n248) v(n249) v(n250) v(n251) v(n252) v(n253) v(n254) v(n255) v(n256) v(n257) v(n258) v(n259) v(n260) v(n261) v(n262) v(n263) v(n264) v(n440) v(n266) v(n267) v(n268) v(n436) v(n270) v(n271) v(n272) v(n273) v(n274) v(n275) v(n276) v(n277) v(n278) v(n279) v(n280) v(n281) v(n282) v(n283) v(n284) v(n285) v(n286) v(n287) v(n288) v(n289) v(n290) v(n291) v(n292) v(n293) v(n294) v(n295) v(n296) v(n297) v(n298) v(n299) v(n300) v(n301) v(n302) v(n303) v(n304) v(n305) v(n306) v(n307) v(n308) v(n309) v(n310) v(n311) v(n312) v(n313) v(n314) v(n315) v(n316) v(n317) v(n318) v(n462) v(n320) v(n321) v(n322) v(n323) v(n324) v(n325) v(n326) v(n327) v(n328) v(n329) v(n330) v(n331) v(n332) v(n333) v(n334) v(n335) v(n336) v(n337) v(n338) v(n339) v(n340) v(n341) v(n342) v(n343) v(n344) v(n345) v(n346) v(n347) v(n348) v(n424) v(n350)
.print tran all
* plot v(gin) v(n0) v(n232) v(n160) v(n201) v(n150) v(n197) v(n199) v(n363) v(n137) v(n180) v(n367) v(n155) v(n224) v(n188) v(n231) v(n217) v(n230) v(n164) v(n138) v(n147) v(n175) v(n215) v(n195) v(n225) v(n189) v(n396) v(n209) v(n222) v(n401) v(n125) v(n167) v(n163) v(n122) v(n124) v(n412) v(n414) v(n213) v(n212) v(n208) v(n143) v(n422) v(n424) v(n191) v(n426) v(n158) v(n165) v(n135) v(n433) v(n435) v(n226) v(n176) v(n206) v(n441) v(n202) v(n154) v(n153) v(n120) v(n186) v(n452) v(n145) v(n131) v(n457) v(n459) v(n207) v(n185) v(n183) v(n128) v(n467) v(n469) v(n151) v(n471) v(n473) v(n177) v(n184) v(n477) v(n129) v(n194) v(n192) v(n484) v(n486) v(n172) v(n488) v(n490) v(n229) v(n228) v(n187) v(n220) v(n203) v(n171) v(n168) v(n149) v(n142) v(n508) v(n510) v(n156) v(n148) v(n514) v(n516) v(n118) v(n518) v(n520) v(n210) v(n190) v(n144) v(n136) v(n117) v(n123) v(n532) v(n534) v(n126) v(n219) v(n198) v(n540) v(n170) v(n200) v(n204) v(n178) v(n549) v(n551) v(n130) v(n553) v(n555) v(n214) v(n211) v(n159) v(n182) v(n169) v(n565) v(n567) v(n146) v(n569) v(n571) v(n157) v(n573) v(n575) v(n227) v(n133) v(n579) v(n581) v(n134) v(n583) v(n193) v(n223) v(n205) v(n196) v(n152) v(n140) v(n139) v(n598) v(n600) v(n127) v(n602) v(n604) v(n181) v(n174) v(n173) v(n119) v(n612) v(n614) v(n221) v(n218) v(n216) v(n141) v(n622) v(n624) v(n166) v(n162) v(n628) v(n630) v(n132) v(n632) v(n634) v(n179) v(n121) v(n161) v(n234) v(n235) v(n236) v(n237) v(n238) v(n239) v(n240) v(n241) v(n242) v(n446) v(n244) v(n245) v(n246) v(n247) v(n248) v(n249) v(n250) v(n251) v(n252) v(n253) v(n254) v(n255) v(n256) v(n257) v(n258) v(n259) v(n260) v(n261) v(n262) v(n263) v(n264) v(n440) v(n266) v(n267) v(n268) v(n436) v(n270) v(n271) v(n272) v(n273) v(n274) v(n275) v(n276) v(n277) v(n278) v(n279) v(n280) v(n281) v(n282) v(n283) v(n284) v(n285) v(n286) v(n287) v(n288) v(n289) v(n290) v(n291) v(n292) v(n293) v(n294) v(n295) v(n296) v(n297) v(n298) v(n299) v(n300) v(n301) v(n302) v(n303) v(n304) v(n305) v(n306) v(n307) v(n308) v(n309) v(n310) v(n311) v(n312) v(n313) v(n314) v(n315) v(n316) v(n317) v(n318) v(n462) v(n320) v(n321) v(n322) v(n323) v(n324) v(n325) v(n326) v(n327) v(n328) v(n329) v(n330) v(n331) v(n332) v(n333) v(n334) v(n335) v(n336) v(n337) v(n338) v(n339) v(n340) v(n341) v(n342) v(n343) v(n344) v(n345) v(n346) v(n347) v(n348) v(n424) v(n350)
.end
