* spice from ispd09f32.H3.res
.include /home/mark/smart.pnrVLSI/ispd09CNS_results/ispd09_benchmarks/tuned_45nm_HP.pm
.subckt inv0 in out vdd
m1  out in  vdd vdd   pmos l=45n w=14.6u
m2  out in  0   0     nmos l=45n w=10.0u
.ends inv0
.subckt inv1 in out vdd
m1  out in  vdd vdd   pmos l=45n w=2.0u
m2  out in  0   0     nmos l=45n w=1.37u
.ends inv1
c0 n0 0 0f
c1 n190 0 35.70755f
c2 n191 0 43.169675f
c3 n192 0 29.10355f
c4 n193 0 30.14355f
c5 n194 0 38.63305f
c6 n195 0 29.3476f
c7 n196 0 43.32445f
c8 n197 0 27.2219f
c9 n198 0 27.11495f
c10 n199 0 41.0222f
c11 n200 0 48.29185f
c12 n201 0 33.61575f
c13 n202 0 44.06775f
c14 n203 0 27.97925f
c15 n204 0 35.4023f
c16 n205 0 47.5017f
c17 n206 0 27.58895f
c18 n207 0 49.37525f
c19 n208 0 49.01705f
c20 n209 0 33.01575f
c21 n210 0 33.5649f
c22 n211 0 34.26315f
c23 n212 0 44.9545f
c24 n213 0 26.22945f
c25 n214 0 37.7607f
c26 n215 0 36.819425f
c27 n216 0 40.20745f
c28 n217 0 44.0999f
c29 n218 0 43.41475f
c30 n219 0 49.6614f
c31 n220 0 36.27045f
c32 n221 0 34.69565f
c33 n222 0 47.42895f
c34 n223 0 48.52785f
c35 n224 0 48.03655f
c36 n225 0 47.08055f
c37 n226 0 28.43135f
c38 n227 0 27.39725f
c39 n228 0 48.25075f
c40 n229 0 39.3808f
c41 n230 0 47.884725f
c42 n231 0 27.57155f
c43 n232 0 29.6607f
c44 n233 0 46.5958f
c45 n234 0 47.20895f
c46 n235 0 25.55035f
c47 n236 0 34.73735625f
c48 n237 0 23.30305f
c49 n238 0 0f
c50 n239 0 34.4223f
c51 n240 0 0f
c52 n241 0 42.9262f
c53 n242 0 40.2993f
c54 n243 0 39.3399f
c55 n244 0 41.87725f
c56 n245 0 46.8454f
c57 n246 0 28.05695f
c58 n247 0 12.95515f
c59 n248 0 31.81625f
c60 n249 0 45.4316f
c61 n250 0 28.97545f
c62 n251 0 29.29965f
c63 n252 0 43.0209f
c64 n253 0 32.65865f
c65 n254 0 27.7067f
c66 n255 0 27.044f
c67 n256 0 33.28665f
c68 n257 0 36.3875f
c69 n258 0 47.3147f
c70 n259 0 34.3065f
c71 n260 0 49.644f
c72 n261 0 30.02575f
c73 n262 0 27.011575f
c74 n263 0 15.84115f
c75 n264 0 1.85995f
c76 n265 0 0f
c77 n266 0 47.7699f
c78 n267 0 42.54815f
c79 n268 0 34.82105f
c80 n269 0 39.28285f
c81 n270 0 27.9584f
c82 n271 0 37.7772f
c83 n272 0 44.4285f
c84 n273 0 33.8705f
c85 n274 0 41.62795f
c86 n275 0 49.18625f
c87 n276 0 0f
c88 n277 0 0f
c89 n278 0 32.44045f
c90 n279 0 33.67215f
c91 n280 0 41.47265f
c92 n281 0 0f
c93 n282 0 31.17395f
c94 n283 0 46.77175f
c95 n284 0 38.2914f
c96 n285 0 2.3929f
c97 n286 0 40.01405f
c98 n287 0 47.4137f
c99 n288 0 33.4877f
c100 n289 0 8.1286f
c101 n290 0 0f
c102 n291 0 0f
c103 n292 0 32.3827f
c104 n293 0 5.043f
c105 n294 0 46.959f
c106 n295 0 27.9173f
c107 n296 0 47.5762f
c108 n297 0 44.07610625f
c109 n298 0 33.84145f
c110 n299 0 42.265f
c111 n300 0 40.91365f
c112 n301 0 47.93445f
c113 n302 0 0f
c114 n303 0 44.70625f
c115 n304 0 0f
c116 n305 0 40.4292f
c117 n306 0 35.64495f
c118 n307 0 0f
c119 n308 0 40.5906f
c120 n309 0 1.3663f
c121 n310 0 45.6689f
c122 n311 0 47.08035f
c123 n312 0 42.6841f
c124 n313 0 38.6911f
c125 n314 0 44.7925f
c126 n315 0 44.031425f
c127 n316 0 32.9766f
c128 n317 0 0f
c129 n318 0 34.39665f
c130 n319 0 42.8068f
c131 n320 0 46.728475f
c132 n321 0 37.944375f
c133 n322 0 26.35625f
c134 n323 0 0f
c135 n324 0 0f
c136 n325 0 45.054575f
c137 n326 0 30.63095f
c138 n327 0 33.532425f
c139 n328 0 26.45815f
c140 n329 0 24.72845f
c141 n330 0 0f
c142 n331 0 37.76485f
c143 n332 0 45.9091f
c144 n333 0 41.0138f
c145 n334 0 3.3299f
c146 n335 0 0f
c147 n336 0 0f
c148 n337 0 35.03715f
c149 n338 0 39.0061f
c150 n339 0 0f
c151 n340 0 44.663575f
c152 n341 0 47.4684f
c153 n342 0 43.61065f
c154 n343 0 40.359825f
c155 n344 0 46.6746375f
c156 n345 0 37.78195f
c157 n346 0 12.0411f
c158 n347 0 0f
c159 n348 0 0f
c160 n349 0 19.66f
c161 n350 0 39.93375f
c162 n351 0 0f
c163 n352 0 0f
c164 n353 0 31.07919375f
c165 n354 0 49.2601f
c166 n355 0 48.69875f
c167 n356 0 46.5318375f
c168 n357 0 0f
c169 n358 0 48.7875f
c170 n359 0 46.786175f
c171 n360 0 0f
c172 n361 0 47.91235f
c173 n362 0 0f
c174 n363 0 0f
c175 n364 0 45.2580875f
c176 n365 0 46.93355f
c177 n366 0 0f
c178 n367 0 42.72345f
c179 n368 0 0f
c180 n369 0 0f
c181 n370 0 48.29121875f
c182 n371 0 40.82545f
c183 n372 0 0f
c184 n373 0 40.1460625f
c185 n374 0 49.2049125f
c186 n375 0 47.67504375f
c187 n376 0 47.696346875f
c188 n377 0 46.950421875f
c189 n378 0 48.950284375f
c190 n570 0 48.9506f
c191 n571 0 47.6973f
c192 n572 0 46.9512f
c193 n574 0 31.07919375f
c194 n575 0 45.9097f
c195 n576 0 43.6108f
c196 n577 0 39.2831f
c197 n578 0 26.3563f
c198 n579 0 32.3828f
c199 n580 0 33.8417f
c200 n581 0 34.653f
c201 n582 0 34.6529f
c202 n583 0 36.1118f
c203 n584 0 8.1286f
c204 n585 0 0f
c205 n586 0 32.0474f
c206 n587 0 0f
c207 n588 0 32.0474f
c208 n589 0 0f
c209 n590 0 35.9262f
c210 n591 0 27.39725f
c211 n592 0 44.45515f
c212 n593 0 44.45515f
c213 n594 0 49.37525f
c214 n596 0 40.4295f
c215 n597 0 44.1004f
c216 n598 0 42.7356f
c217 n599 0 42.7356f
c218 n600 0 47.0889f
c219 n601 0 47.20895f
c220 n602 0 0f
c221 n603 0 46.96865f
c222 n604 0 0f
c223 n605 0 46.96865f
c224 n606 0 0f
c225 n607 0 40.18385f
c226 n608 0 0f
c227 n609 0 40.18385f
c228 n611 0 34.7376f
c229 n612 0 48.16615f
c230 n613 0 48.16615f
c231 n615 0 44.0763f
c232 n616 0 34.4226f
c233 n617 0 31.8163f
c234 n618 0 25.8893f
c235 n619 0 25.8893f
c236 n620 0 46.5662f
c237 n621 0 46.5662f
c238 n622 0 0f
c239 n623 0 24.28429375f
c240 n625 0 48.293f
c241 n626 0 47.6753f
c242 n627 0 42.7238f
c243 n628 0 40.8256f
c244 n629 0 48.6988f
c245 n630 0 46.7866f
c246 n631 0 43.1698f
c247 n633 0 36.8196f
c248 n634 0 46.728475f
c249 n635 0 0f
c250 n636 0 0.31315f
c251 n638 0 42.3214f
c252 n639 0 40.3f
c253 n640 0 0f
c254 n641 0 25.2037f
c255 n642 0 0f
c256 n643 0 25.2037f
c257 n644 0 0f
c258 n645 0 42.22975f
c259 n646 0 0f
c260 n647 0 42.22975f
c261 n648 0 31.3926f
c262 n649 0 31.3926f
c263 n650 0 30.63095f
c264 n652 0 42.2657f
c265 n653 0 37.782f
c266 n654 0 0f
c267 n655 0 48.1847f
c268 n656 0 34.8211f
c269 n657 0 37.456f
c270 n658 0 27.57155f
c271 n659 0 0f
c272 n660 0 47.3402f
c273 n661 0 0f
c274 n662 0 47.3402f
c275 n663 0 0f
c276 n664 0 42.1771f
c277 n665 0 39.3808f
c278 n666 0 44.97325f
c279 n667 0 44.97325f
c280 n668 0 49.6442f
c281 n669 0 30.0258f
c282 n670 0 27.9794f
c283 n671 0 27.5891f
c284 n672 0 39.5068f
c285 n673 0 39.5068f
c286 n674 0 38.7262f
c287 n675 0 38.7262f
c288 n676 0 0f
c289 n677 0 27.7241f
c290 n678 0 0f
c291 n679 0 27.7242f
c292 n681 0 33.0159f
c293 n682 0 0f
c294 n683 0 40.95055f
c295 n684 0 0f
c296 n685 0 40.95055f
c297 n687 0 24.72845f
c298 n688 0 46.959f
c299 n689 0 43.4149f
c300 n690 0 0f
c301 n691 0 42.9152f
c302 n692 0 0f
c303 n693 0 42.9152f
c304 n694 0 0f
c305 n695 0 41.393f
c306 n696 0 40.20745f
c307 n697 0 42.5784f
c308 n698 0 42.5784f
c309 n699 0 44.7927f
c310 n700 0 45.6692f
c311 n701 0 0f
c312 n702 0 44.9217f
c313 n703 0 34.3065f
c314 n704 0 27.7685f
c315 n705 0 27.7684f
c316 n706 0 37.7772f
c317 n708 0 33.4879f
c318 n709 0 35.6453f
c319 n710 0 0f
c320 n711 0 35.7129f
c321 n712 0 0f
c322 n713 0 35.7129f
c323 n714 0 0f
c324 n715 0 38.9489f
c325 n716 0 41.0222f
c326 n717 0 36.8755f
c327 n718 0 36.8755f
c328 n719 0 31.8257f
c329 n720 0 30.14355f
c330 n721 0 0f
c331 n722 0 33.50785f
c332 n723 0 0f
c333 n724 0 33.50785f
c334 n726 0 46.6748f
c335 n727 0 32.6589f
c336 n729 0 47.5762f
c337 n730 0 35.0375f
c338 n731 0 40.91365f
c339 n732 0 43.4446f
c340 n733 0 0f
c341 n734 0 44.71f
c342 n735 0 39.3399f
c343 n736 0 25.04f
c344 n737 0 25.04f
c345 n738 0 46.3586f
c346 n739 0 42.9262f
c347 n740 0 0f
c348 n741 0 49.79085f
c349 n742 0 0f
c350 n743 0 49.79085f
c351 n744 0 26.2297f
c352 n745 0 46.5958f
c353 n746 0 47.4431f
c354 n747 0 47.4431f
c355 n748 0 41.57975f
c356 n749 0 41.57975f
c357 n750 0 45.2586f
c358 n751 0 46.5324f
c359 n752 0 49.1865f
c360 n753 0 38.6912f
c361 n754 0 45.4316f
c362 n755 0 38.2915f
c363 n756 0 0f
c364 n757 0 30.7428f
c365 n758 0 0f
c366 n759 0 30.7428f
c367 n760 0 48.52785f
c368 n761 0 41.87725f
c369 n762 0 25.3799f
c370 n763 0 25.3798f
c371 n764 0 44.10895f
c372 n765 0 44.10895f
c373 n766 0 28.0571f
c374 n767 0 47.7699f
c375 n768 0 0f
c376 n769 0 29.4064f
c377 n770 0 0f
c378 n771 0 29.4064f
c379 n772 0 0f
c380 n773 0 25.2343f
c381 n774 0 0f
c382 n775 0 25.2343f
c383 n776 0 27.011575f
c384 n778 0 45.0548f
c385 n779 0 40.3599f
c386 n781 0 27.222f
c387 n782 0 36.59815f
c388 n783 0 36.59815f
c389 n784 0 26.4583f
c390 n785 0 46.8459f
c391 n786 0 0f
c392 n787 0 48.81375f
c393 n788 0 0f
c394 n789 0 48.81375f
c395 n790 0 33.616f
c396 n791 0 31.1741f
c397 n792 0 37.0433f
c398 n793 0 25.55035f
c399 n794 0 0f
c400 n795 0 48.5361f
c401 n796 0 0f
c402 n797 0 48.5361f
c403 n798 0 35.58675f
c404 n799 0 35.58675f
c405 n800 0 40.591f
c406 n801 0 34.3968f
c407 n803 0 23.30305f
c408 n804 0 0f
c409 n805 0 27.4296f
c410 n806 0 0f
c411 n807 0 27.4296f
c412 n808 0 47.4291f
c413 n809 0 47.0806f
c414 n810 0 44.34955f
c415 n811 0 44.34955f
c416 n812 0 43.65265f
c417 n813 0 43.65265f
c418 n814 0 44.8771f
c419 n815 0 27.1151f
c420 n816 0 0f
c421 n817 0 35.524f
c422 n818 0 0f
c423 n819 0 35.524f
c424 n820 0 26.3513f
c425 n821 0 26.3513f
c426 n822 0 40.1464f
c427 n823 0 49.205f
c428 n825 0 37.945f
c429 n826 0 29.3476f
c430 n828 0 40.0142f
c431 n829 0 47.414f
c432 n830 0 31.7632f
c433 n831 0 31.7632f
c434 n832 0 29.5115f
c435 n834 0 0f
c436 n835 0 37.4761f
c437 n836 0 34.6957f
c438 n837 0 43.03685f
c439 n838 0 43.03685f
c440 n839 0 0f
c441 n840 0 35.15125f
c442 n841 0 0f
c443 n842 0 35.15125f
c444 n843 0 47.884725f
c445 n845 0 44.6639f
c446 n846 0 47.469f
c447 n847 0 44.0317f
c448 n848 0 33.5325f
c449 n849 0 47.5018f
c450 n850 0 27.9586f
c451 n851 0 38.9006f
c452 n852 0 29.6607f
c453 n853 0 0f
c454 n854 0 48.1404f
c455 n855 0 0f
c456 n856 0 48.1404f
c457 n857 0 38.7146f
c458 n858 0 38.7146f
c459 n859 0 1.85995f
c460 n861 0 35.4028f
c461 n862 0 34.2633f
c462 n863 0 0f
c463 n864 0 40.9509f
c464 n865 0 0f
c465 n866 0 40.9509f
c466 n867 0 0f
c467 n868 0 37.53275f
c468 n869 0 0f
c469 n870 0 37.53275f
c470 n871 0 29.4205f
c471 n872 0 29.4205f
c472 n873 0 37.765f
c473 n874 0 39.0063f
c474 n875 0 48.29185f
c475 n877 0 38.6332f
c476 n878 0 47.9345f
c477 n879 0 0f
c478 n880 0 46.1304f
c479 n881 0 48.25075f
c480 n882 0 44.01005f
c481 n883 0 44.01005f
c482 n884 0 0f
c483 n885 0 33.5971f
c484 n886 0 0f
c485 n887 0 33.5971f
c486 n888 0 37.4429f
c487 n889 0 37.4429f
c488 n891 0 47.3147f
c489 n892 0 26.8088f
c490 n893 0 26.8088f
c491 n894 0 43.0211f
c492 n895 0 33.8709f
c493 n896 0 0f
c494 n897 0 39.3838f
c495 n898 0 37.7607f
c496 n899 0 41.0069f
c497 n900 0 41.0069f
c498 n901 0 0f
c499 n902 0 25.6585f
c500 n903 0 0f
c501 n904 0 25.6584f
c502 n905 0 0f
c503 n906 0 45.99645f
c504 n907 0 0f
c505 n908 0 45.99645f
c506 n909 0 44.4289f
c507 n911 0 5.043f
c508 n913 0 48.7878f
c509 n914 0 46.9338f
c510 n916 0 12.95515f
c511 n917 0 0f
c512 n918 0 25.7155f
c513 n919 0 0f
c514 n920 0 25.7155f
c515 n922 0 36.2705f
c516 n923 0 43.5045f
c517 n924 0 43.5045f
c518 n925 0 42.8073f
c519 n926 0 3.3299f
c520 n927 0 0f
c521 n928 0 42.3647f
c522 n930 0 47.9125f
c523 n931 0 49.2601f
c524 n932 0 19.66f
c525 n933 0 42.6843f
c526 n934 0 47.2839f
c527 n935 0 1.3663f
c528 n936 0 0f
c529 n937 0 46.6008f
c530 n938 0 49.6614f
c531 n939 0 43.53995f
c532 n940 0 43.53995f
c533 n942 0 32.4405f
c534 n943 0 0f
c535 n944 0 40.3944f
c536 n945 0 28.97545f
c537 n946 0 25.9068f
c538 n947 0 25.9067f
c539 n948 0 39.9339f
c540 n949 0 46.7721f
c541 n950 0 36.5816f
c542 n951 0 28.43135f
c543 n952 0 0f
c544 n953 0 44.73155f
c545 n954 0 0f
c546 n955 0 44.73155f
c547 n956 0 35.7077f
c548 n957 0 41.47265f
c549 n958 0 0f
c550 n959 0 29.5215f
c551 n960 0 0f
c552 n961 0 29.5215f
c553 n962 0 0f
c554 n963 0 29.10025f
c555 n964 0 0f
c556 n965 0 29.10025f
c557 n966 0 47.0807f
c558 n967 0 41.014f
c559 n968 0 33.6723f
c560 n969 0 32.9767f
c561 n970 0 0f
c562 n971 0 44.8119f
c563 n972 0 29.1036f
c564 n973 0 31.41635f
c565 n974 0 31.41635f
c566 n975 0 0f
c567 n976 0 44.1162f
c568 n977 0 33.28665f
c569 n978 0 27.473f
c570 n979 0 27.4729f
c571 n980 0 49.0171f
c572 n981 0 27.707f
c573 n982 0 44.06775f
c574 n983 0 29.29965f
c575 n984 0 26.3318f
c576 n985 0 26.3318f
c577 n986 0 37.8954f
c578 n987 0 37.8954f
c579 n988 0 0f
c580 n989 0 39.3427f
c581 n990 0 0f
c582 n991 0 39.3427f
c583 n992 0 41.6281f
c584 n993 0 27.9173f
c585 n994 0 42.3711f
c586 n995 0 44.9545f
c587 n996 0 0f
c588 n997 0 39.78755f
c589 n998 0 0f
c590 n999 0 39.78755f
c591 n1000 0 28.6603f
c592 n1001 0 28.6603f
c593 n1002 0 12.0411f
c594 n1004 0 42.5487f
c595 n1005 0 44.7063f
c596 n1006 0 33.5649f
c597 n1007 0 27.0441f
c598 n1008 0 0f
c599 n1009 0 26.7771f
c600 n1010 0 0f
c601 n1011 0 26.7771f
c602 n1012 0 0f
c603 n1013 0 40.51235f
c604 n1014 0 0f
c605 n1015 0 40.51235f
c606 n1016 0 35.7834f
c607 n1017 0 15.84115f
c608 n1018 0 0f
c609 n1019 0 27.8628f
c610 n1020 0 0f
c611 n1021 0 27.8628f
c612 n1022 0 0f
c613 n1023 0 39.0594f
c614 n1024 0 0f
c615 n1025 0 39.0594f
c616 n1026 0 0f
c617 n1027 0 41.08f
c618 n1028 0 2.3929f
c619 n1029 0 39.8836f
c620 n1030 0 43.32445f
c621 n1031 0 0f
c622 n1032 0 36.44255f
c623 n1033 0 0f
c624 n1034 0 36.44255f
c625 n1035 0 48.03655f
c626 n1036 0 36.3875f
c627 n1037 0 0f
c628 n1038 0 27.6704f
c629 n1039 0 0f
c630 n1040 0 27.6704f
c631 n1041 0 0f
c632 n1042 0 43.69165f
c633 n1043 0 0f
c634 n1044 0 43.69165f
c635 n380 0 60.6583f
c636 n381 0 61.8088f
c637 n382 0 76.0069f
c638 n383 0 76.0069f
c639 n384 0 79.8116f
c640 n385 0 66.41635f
c641 n386 0 77.37095f
c642 n387 0 74.78755f
c643 n388 0 74.78755f
c644 n389 0 64.10025f
c645 n390 0 64.52135f
c646 n391 0 60.03995f
c647 n392 0 78.4443f
c648 n393 0 82.4431f
c649 n394 0 82.4431f
c650 n395 0 64.40635f
c651 n396 0 64.40635f
c652 n397 0 60.6584f
c653 n398 0 61.8088f
c654 n399 0 74.3838f
c655 n400 0 62.4727f
c656 n401 0 62.4728f
c657 n402 0 66.41635f
c658 n403 0 63.6603f
c659 n404 0 63.6603f
c660 n405 0 82.28375f
c661 n406 0 64.10025f
c662 n407 0 64.52135f
c663 n408 0 60.03995f
c664 n409 0 79.70985f
c665 n410 0 76.57975f
c666 n411 0 76.57975f
c667 n412 0 60.2343f
c668 n413 0 60.2343f
c669 n414 0 68.5971f
c670 n415 0 81.1304f
c671 n416 0 79.01005f
c672 n417 0 79.01005f
c673 n418 0 79.11615f
c674 n419 0 77.36455f
c675 n420 0 60.7154f
c676 n421 0 60.7154f
c677 n422 0 78.53995f
c678 n423 0 81.60055f
c679 n424 0 60.90655f
c680 n425 0 75.3944f
c681 n426 0 84.79085f
c682 n427 0 84.79085f
c683 n428 0 79.10895f
c684 n429 0 79.10895f
c685 n430 0 65.7427f
c686 n431 0 68.5971f
c687 n432 0 72.4429f
c688 n433 0 72.4429f
c689 n434 0 72.8954f
c690 n435 0 72.8954f
c691 n436 0 74.3427f
c692 n437 0 78.5045f
c693 n438 0 78.5045f
c694 n439 0 78.53995f
c695 n440 0 71.5813f
c696 n441 0 60.90665f
c697 n442 0 83.81375f
c698 n443 0 83.81375f
c699 n444 0 81.35845f
c700 n445 0 60.37965f
c701 n446 0 60.37975f
c702 n447 0 65.7427f
c703 n448 0 66.76305f
c704 n449 0 66.76305f
c705 n450 0 80.99645f
c706 n451 0 61.3317f
c707 n452 0 61.3317f
c708 n453 0 74.3427f
c709 n454 0 76.0799f
c710 n455 0 71.44255f
c711 n456 0 70.78335f
c712 n457 0 79.73155f
c713 n458 0 79.73155f
c714 n459 0 71.59815f
c715 n460 0 71.59815f
c716 n461 0 61.35115f
c717 n462 0 79.34955f
c718 n463 0 62.42945f
c719 n464 0 78.65265f
c720 n465 0 70.15125f
c721 n466 0 70.15125f
c722 n467 0 80.99645f
c723 n468 0 73.7146f
c724 n469 0 72.53275f
c725 n470 0 72.53275f
c726 n471 0 74.8834f
c727 n472 0 71.44255f
c728 n473 0 62.8628f
c729 n474 0 62.8628f
c730 n475 0 70.58675f
c731 n476 0 70.58675f
c732 n477 0 72.04315f
c733 n478 0 61.35115f
c734 n479 0 79.34955f
c735 n480 0 62.42945f
c736 n481 0 78.65265f
c737 n482 0 78.03685f
c738 n483 0 64.5113f
c739 n484 0 83.1404f
c740 n485 0 73.7146f
c741 n486 0 64.4203f
c742 n487 0 64.4203f
c743 n488 0 62.6703f
c744 n489 0 78.69165f
c745 n490 0 74.0593f
c746 n491 0 61.77695f
c747 n492 0 61.77695f
c748 n493 0 83.5361f
c749 n494 0 83.5361f
c750 n495 0 79.87695f
c751 n496 0 70.524f
c752 n497 0 70.524f
c753 n498 0 70.9262f
c754 n499 0 78.03685f
c755 n500 0 72.476f
c756 n501 0 83.1404f
c757 n502 0 73.9005f
c758 n503 0 75.9509f
c759 n504 0 75.9509f
c760 n505 0 62.6703f
c761 n506 0 78.69165f
c762 n507 0 74.0593f
c763 n508 0 75.51235f
c764 n509 0 75.51235f
c765 n510 0 60.88925f
c766 n511 0 81.5662f
c767 n512 0 83.16615f
c768 n513 0 83.16615f
c769 n514 0 79.45515f
c770 n515 0 79.45515f
c771 n516 0 60.88925f
c772 n517 0 81.5662f
c773 n518 0 59.28429375f
c774 n519 0 67.0474f
c775 n520 0 67.0474f
c776 n521 0 69.65275f
c777 n522 0 77.7356f
c778 n523 0 82.0887f
c779 n524 0 81.96865f
c780 n525 0 81.96865f
c781 n526 0 71.1116f
c782 n527 0 69.65285f
c783 n528 0 77.7356f
c784 n529 0 75.18385f
c785 n530 0 75.18385f
c786 n531 0 76.39285f
c787 n532 0 79.9216f
c788 n533 0 62.7683f
c789 n534 0 70.71275f
c790 n535 0 66.8257f
c791 n536 0 77.5784f
c792 n537 0 77.5784f
c793 n538 0 77.9152f
c794 n539 0 62.7684f
c795 n540 0 70.71275f
c796 n541 0 68.50785f
c797 n542 0 68.50785f
c798 n543 0 75.95055f
c799 n544 0 77.9152f
c800 n545 0 60.20365f
c801 n546 0 71.8755f
c802 n547 0 71.8755f
c803 n548 0 73.9488f
c804 n549 0 75.95055f
c805 n550 0 77.22975f
c806 n551 0 60.20365f
c807 n552 0 83.1845f
c808 n553 0 62.7241f
c809 n554 0 73.7262f
c810 n555 0 73.7262f
c811 n556 0 77.22975f
c812 n557 0 35.31315f
c813 n558 0 82.3402f
c814 n559 0 62.724f
c815 n560 0 74.5068f
c816 n561 0 74.5068f
c817 n562 0 66.3926f
c818 n563 0 66.3926f
c819 n564 0 82.3402f
c820 n565 0 72.45575f
c821 n566 0 77.17695f
c822 n567 0 79.97325f
c823 n568 0 79.97325f
c824 n569 0 77.32105f
c825 nSEG_NODE_855 0 97.9012f
c826 nSEG_NODE_856 0 97.9012f
c827 nSEG_NODE_857 0 97.9012f
c828 nSEG_NODE_858 0 97.9012f
c829 nSEG_NODE_859 0 97.9012f
c830 nSEG_NODE_860 0 97.9012f
c831 nSEG_NODE_861 0 97.9012f
c832 nSEG_NODE_862 0 97.9012f
c833 nSEG_NODE_863 0 97.9012f
c834 nSEG_NODE_864 0 97.9012f
c835 nSEG_NODE_865 0 97.9012f
c836 nSEG_NODE_866 0 97.9012f
c837 nSEG_NODE_867 0 97.9012f
c838 nSEG_NODE_868 0 97.9012f
c839 nSEG_NODE_869 0 97.9012f
c840 nSEG_NODE_870 0 97.9012f
c841 nSEG_NODE_871 0 97.9012f
c842 nSEG_NODE_872 0 97.9012f
c843 nSEG_NODE_873 0 97.9012f
c844 nSEG_NODE_874 0 97.9012f
c845 nSEG_NODE_875 0 97.9012f
c846 nSEG_NODE_876 0 97.9012f
c847 nSEG_NODE_877 0 97.9012f
c848 nSEG_NODE_878 0 97.9012f
c849 nSEG_NODE_879 0 97.9012f
c850 nSEG_NODE_880 0 97.9012f
c851 nSEG_NODE_881 0 97.9012f
c852 nSEG_NODE_882 0 97.9012f
c853 nSEG_NODE_883 0 97.9012f
c854 nSEG_NODE_884 0 97.9012f
c855 nSEG_NODE_885 0 97.900884375f
c856 nSEG_NODE_886 0 95.3946f
c857 nSEG_NODE_887 0 95.3946f
c858 nSEG_NODE_888 0 95.3946f
c859 nSEG_NODE_889 0 95.3946f
c860 nSEG_NODE_890 0 95.3946f
c861 nSEG_NODE_891 0 95.3946f
c862 nSEG_NODE_892 0 95.3946f
c863 nSEG_NODE_893 0 95.3946f
c864 nSEG_NODE_894 0 95.3946f
c865 nSEG_NODE_895 0 95.3946f
c866 nSEG_NODE_896 0 95.393646875f
c867 nSEG_NODE_897 0 93.9024f
c868 nSEG_NODE_898 0 93.9024f
c869 nSEG_NODE_899 0 93.9024f
c870 nSEG_NODE_900 0 93.9024f
c871 nSEG_NODE_901 0 93.9024f
c872 nSEG_NODE_902 0 93.9024f
c873 nSEG_NODE_903 0 93.9024f
c874 nSEG_NODE_904 0 93.9024f
c875 nSEG_NODE_905 0 93.9024f
c876 nSEG_NODE_906 0 93.9024f
c877 nSEG_NODE_907 0 93.9024f
c878 nSEG_NODE_908 0 93.901621875f
c879 nSEG_NODE_909 0 91.8194f
c880 nSEG_NODE_910 0 91.8194f
c881 nSEG_NODE_911 0 91.8194f
c882 nSEG_NODE_912 0 91.8194f
c883 nSEG_NODE_913 0 91.8188f
c884 nSEG_NODE_914 0 87.2216f
c885 nSEG_NODE_915 0 87.2216f
c886 nSEG_NODE_916 0 87.2216f
c887 nSEG_NODE_917 0 87.22145f
c888 nSEG_NODE_918 0 78.5662f
c889 nSEG_NODE_919 0 78.56595f
c890 nSEG_NODE_920 0 52.71255f
c891 nSEG_NODE_921 0 64.7655f
c892 nSEG_NODE_922 0 67.68315f
c893 nSEG_NODE_923 0 69.30575f
c894 nSEG_NODE_924 0 69.30575f
c895 nSEG_NODE_925 0 72.2234f
c896 nSEG_NODE_926 0 64.0948f
c897 nSEG_NODE_927 0 64.0948f
c898 nSEG_NODE_928 0 71.8524f
c899 nSEG_NODE_929 0 80.8587f
c900 nSEG_NODE_930 0 88.2008f
c901 nSEG_NODE_931 0 88.2003f
c902 nSEG_NODE_932 0 94.1776f
c903 nSEG_NODE_933 0 69.4752f
c904 nSEG_NODE_934 0 69.47495625f
c905 nSEG_NODE_935 0 88.1526f
c906 nSEG_NODE_936 0 88.1526f
c907 nSEG_NODE_937 0 88.15240625f
c908 nSEG_NODE_938 0 68.8449f
c909 nSEG_NODE_939 0 63.63255f
c910 nSEG_NODE_940 0 51.77855f
c911 nSEG_NODE_941 0 51.77855f
c912 nSEG_NODE_942 0 96.586f
c913 nSEG_NODE_943 0 96.586f
c914 nSEG_NODE_944 0 96.586f
c915 nSEG_NODE_945 0 96.586f
c916 nSEG_NODE_946 0 96.586f
c917 nSEG_NODE_947 0 96.586f
c918 nSEG_NODE_948 0 96.586f
c919 nSEG_NODE_949 0 96.586f
c920 nSEG_NODE_950 0 96.586f
c921 nSEG_NODE_951 0 96.586f
c922 nSEG_NODE_952 0 96.58421875f
c923 nSEG_NODE_953 0 95.3506f
c924 nSEG_NODE_954 0 95.3506f
c925 nSEG_NODE_955 0 95.3506f
c926 nSEG_NODE_956 0 95.3506f
c927 nSEG_NODE_957 0 95.3506f
c928 nSEG_NODE_958 0 95.3506f
c929 nSEG_NODE_959 0 95.3506f
c930 nSEG_NODE_960 0 95.3506f
c931 nSEG_NODE_961 0 95.3506f
c932 nSEG_NODE_962 0 95.3506f
c933 nSEG_NODE_963 0 95.35034375f
c934 nSEG_NODE_964 0 85.4476f
c935 nSEG_NODE_965 0 85.4476f
c936 nSEG_NODE_966 0 85.4476f
c937 nSEG_NODE_967 0 85.44725f
c938 nSEG_NODE_968 0 81.65105f
c939 nSEG_NODE_969 0 97.3976f
c940 nSEG_NODE_970 0 97.39755f
c941 nSEG_NODE_971 0 93.5732f
c942 nSEG_NODE_972 0 93.5732f
c943 nSEG_NODE_973 0 93.5732f
c944 nSEG_NODE_974 0 93.572775f
c945 nSEG_NODE_975 0 86.339475f
c946 nSEG_NODE_976 0 73.6392f
c947 nSEG_NODE_977 0 73.639025f
c948 nSEG_NODE_978 0 84.6428f
c949 nSEG_NODE_979 0 84.6428f
c950 nSEG_NODE_980 0 84.6428f
c951 nSEG_NODE_981 0 84.64245f
c952 nSEG_NODE_982 0 80.6f
c953 nSEG_NODE_983 0 80.6f
c954 nSEG_NODE_984 0 80.5993f
c955 nSEG_NODE_985 0 50.40735f
c956 nSEG_NODE_986 0 50.40735f
c957 nSEG_NODE_987 0 84.5314f
c958 nSEG_NODE_988 0 84.5314f
c959 nSEG_NODE_989 0 84.5314f
c960 nSEG_NODE_990 0 84.5307f
c961 nSEG_NODE_991 0 75.564f
c962 nSEG_NODE_992 0 75.564f
c963 nSEG_NODE_993 0 75.56395f
c964 nSEG_NODE_994 0 96.3694f
c965 nSEG_NODE_995 0 96.3692f
c966 nSEG_NODE_996 0 69.64215f
c967 nSEG_NODE_997 0 74.91175f
c968 nSEG_NODE_998 0 84.35405f
c969 nSEG_NODE_999 0 99.2882f
c970 nSEG_NODE_1000 0 60.05155f
c971 nSEG_NODE_1001 0 55.95865f
c972 nSEG_NODE_1002 0 55.17805f
c973 nSEG_NODE_1003 0 55.4482f
c974 nSEG_NODE_1004 0 55.4482f
c975 nSEG_NODE_1005 0 66.03165f
c976 nSEG_NODE_1006 0 86.82965f
c977 nSEG_NODE_1007 0 82.78585f
c978 nSEG_NODE_1008 0 89.5854f
c979 nSEG_NODE_1009 0 89.5854f
c980 nSEG_NODE_1010 0 89.5854f
c981 nSEG_NODE_1011 0 89.5852f
c982 nSEG_NODE_1012 0 91.3384f
c983 nSEG_NODE_1013 0 91.3384f
c984 nSEG_NODE_1014 0 91.3384f
c985 nSEG_NODE_1015 0 91.3384f
c986 nSEG_NODE_1016 0 91.3381f
c987 nSEG_NODE_1017 0 89.8433f
c988 nSEG_NODE_1018 0 55.5368f
c989 nSEG_NODE_1019 0 55.5368f
c990 nSEG_NODE_1020 0 66.9758f
c991 nSEG_NODE_1021 0 66.9756f
c992 nSEG_NODE_1022 0 71.2906f
c993 nSEG_NODE_1023 0 71.29025f
c994 nSEG_NODE_1024 0 71.42565f
c995 nSEG_NODE_1025 0 71.42565f
c996 nSEG_NODE_1026 0 77.8977f
c997 nSEG_NODE_1027 0 63.6514f
c998 nSEG_NODE_1028 0 93.3496f
c999 nSEG_NODE_1029 0 93.3494375f
c1000 nSEG_NODE_1030 0 65.31755f
c1001 nSEG_NODE_1031 0 95.1524f
c1002 nSEG_NODE_1032 0 95.1524f
c1003 nSEG_NODE_1033 0 70.075f
c1004 nSEG_NODE_1034 0 70.07465f
c1005 nSEG_NODE_1035 0 86.8892f
c1006 nSEG_NODE_1036 0 86.8889f
c1007 nSEG_NODE_1037 0 89.41985f
c1008 nSEG_NODE_1038 0 50.07995f
c1009 nSEG_NODE_1039 0 50.07995f
c1010 nSEG_NODE_1040 0 92.71705f
c1011 nSEG_NODE_1041 0 52.45915f
c1012 nSEG_NODE_1042 0 90.5172f
c1013 nSEG_NODE_1043 0 90.5172f
c1014 nSEG_NODE_1044 0 90.5172f
c1015 nSEG_NODE_1045 0 90.5172f
c1016 nSEG_NODE_1046 0 90.5166875f
c1017 nSEG_NODE_1047 0 93.0648f
c1018 nSEG_NODE_1048 0 93.0648f
c1019 nSEG_NODE_1049 0 93.0648f
c1020 nSEG_NODE_1050 0 93.0642375f
c1021 nSEG_NODE_1051 0 98.373f
c1022 nSEG_NODE_1052 0 98.37275f
c1023 nSEG_NODE_1053 0 77.3824f
c1024 nSEG_NODE_1054 0 77.3823f
c1025 nSEG_NODE_1055 0 76.5829f
c1026 nSEG_NODE_1056 0 61.4855f
c1027 nSEG_NODE_1057 0 61.4855f
c1028 nSEG_NODE_1058 0 50.75955f
c1029 nSEG_NODE_1059 0 50.75955f
c1030 nSEG_NODE_1060 0 56.11405f
c1031 nSEG_NODE_1061 0 58.81275f
c1032 nSEG_NODE_1062 0 58.81275f
c1033 nSEG_NODE_1063 0 50.4686f
c1034 nSEG_NODE_1064 0 50.4686f
c1035 nSEG_NODE_1065 0 90.109375f
c1036 nSEG_NODE_1066 0 80.7198f
c1037 nSEG_NODE_1067 0 80.7198f
c1038 nSEG_NODE_1068 0 80.719725f
c1039 nSEG_NODE_1069 0 54.4439f
c1040 nSEG_NODE_1070 0 52.91645f
c1041 nSEG_NODE_1071 0 93.6918f
c1042 nSEG_NODE_1072 0 93.6913f
c1043 nSEG_NODE_1073 0 67.232f
c1044 nSEG_NODE_1074 0 67.23175f
c1045 nSEG_NODE_1075 0 62.34805f
c1046 nSEG_NODE_1076 0 74.08645f
c1047 nSEG_NODE_1077 0 81.182f
c1048 nSEG_NODE_1078 0 81.1816f
c1049 nSEG_NODE_1079 0 68.7936f
c1050 nSEG_NODE_1080 0 68.79345f
c1051 nSEG_NODE_1081 0 54.85905f
c1052 nSEG_NODE_1082 0 54.85905f
c1053 nSEG_NODE_1083 0 94.85805f
c1054 nSEG_NODE_1084 0 94.16115f
c1055 nSEG_NODE_1085 0 89.75405f
c1056 nSEG_NODE_1086 0 54.23005f
c1057 nSEG_NODE_1087 0 52.70245f
c1058 nSEG_NODE_1088 0 52.70245f
c1059 nSEG_NODE_1089 0 80.2928f
c1060 nSEG_NODE_1090 0 80.2928f
c1061 nSEG_NODE_1091 0 80.2928f
c1062 nSEG_NODE_1092 0 80.2924625f
c1063 nSEG_NODE_1093 0 98.41f
c1064 nSEG_NODE_1094 0 98.41f
c1065 nSEG_NODE_1095 0 98.41f
c1066 nSEG_NODE_1096 0 98.41f
c1067 nSEG_NODE_1097 0 98.4099125f
c1068 nSEG_NODE_1098 0 75.89f
c1069 nSEG_NODE_1099 0 75.89f
c1070 nSEG_NODE_1100 0 75.889375f
c1071 nSEG_NODE_1101 0 80.0284f
c1072 nSEG_NODE_1102 0 80.02825f
c1073 nSEG_NODE_1103 0 94.828f
c1074 nSEG_NODE_1104 0 94.8277f
c1075 nSEG_NODE_1105 0 63.52625f
c1076 nSEG_NODE_1106 0 63.52625f
c1077 nSEG_NODE_1107 0 59.0228f
c1078 nSEG_NODE_1108 0 74.9522f
c1079 nSEG_NODE_1109 0 74.9521f
c1080 nSEG_NODE_1110 0 69.39135f
c1081 nSEG_NODE_1111 0 89.3278f
c1082 nSEG_NODE_1112 0 89.3278f
c1083 nSEG_NODE_1113 0 89.3278f
c1084 nSEG_NODE_1114 0 89.3278f
c1085 nSEG_NODE_1115 0 89.3278f
c1086 nSEG_NODE_1116 0 89.327475f
c1087 nSEG_NODE_1117 0 94.938f
c1088 nSEG_NODE_1118 0 94.938f
c1089 nSEG_NODE_1119 0 94.938f
c1090 nSEG_NODE_1120 0 94.938f
c1091 nSEG_NODE_1121 0 94.938f
c1092 nSEG_NODE_1122 0 94.9374f
c1093 nSEG_NODE_1123 0 88.0634f
c1094 nSEG_NODE_1124 0 88.063125f
c1095 nSEG_NODE_1125 0 67.065f
c1096 nSEG_NODE_1126 0 67.064925f
c1097 nSEG_NODE_1127 0 95.0035f
c1098 nSEG_NODE_1128 0 55.917f
c1099 nSEG_NODE_1129 0 77.8011f
c1100 nSEG_NODE_1130 0 70.8056f
c1101 nSEG_NODE_1131 0 70.8051f
c1102 nSEG_NODE_1132 0 68.5266f
c1103 nSEG_NODE_1133 0 68.52645f
c1104 nSEG_NODE_1134 0 58.8408f
c1105 nSEG_NODE_1135 0 58.8408f
c1106 nSEG_NODE_1136 0 75.53f
c1107 nSEG_NODE_1137 0 75.52985f
c1108 nSEG_NODE_1138 0 78.0126f
c1109 nSEG_NODE_1139 0 78.0124f
c1110 nSEG_NODE_1140 0 77.2664f
c1111 nSEG_NODE_1141 0 77.2664f
c1112 nSEG_NODE_1142 0 77.26625f
c1113 nSEG_NODE_1143 0 95.86895f
c1114 nSEG_NODE_1144 0 92.2608f
c1115 nSEG_NODE_1145 0 53.6176f
c1116 nSEG_NODE_1146 0 53.6176f
c1117 nSEG_NODE_1147 0 86.0422f
c1118 nSEG_NODE_1148 0 86.042f
c1119 nSEG_NODE_1149 0 67.7418f
c1120 nSEG_NODE_1150 0 67.7414f
c1121 nSEG_NODE_1151 0 78.7676f
c1122 nSEG_NODE_1152 0 51.3168f
c1123 nSEG_NODE_1153 0 51.3168f
c1124 nSEG_NODE_1154 0 88.8578f
c1125 nSEG_NODE_1155 0 88.8578f
c1126 nSEG_NODE_1156 0 88.8578f
c1127 nSEG_NODE_1157 0 88.8574f
c1128 nSEG_NODE_1158 0 97.5756f
c1129 nSEG_NODE_1159 0 97.5756f
c1130 nSEG_NODE_1160 0 97.5756f
c1131 nSEG_NODE_1161 0 97.5756f
c1132 nSEG_NODE_1162 0 97.5756f
c1133 nSEG_NODE_1163 0 97.5756f
c1134 nSEG_NODE_1164 0 97.5753f
c1135 nSEG_NODE_1165 0 93.8676f
c1136 nSEG_NODE_1166 0 93.8676f
c1137 nSEG_NODE_1167 0 93.8676f
c1138 nSEG_NODE_1168 0 93.86735f
c1139 nSEG_NODE_1169 0 51.4309f
c1140 nSEG_NODE_1170 0 51.4309f
c1141 nSEG_NODE_1171 0 72.541f
c1142 nSEG_NODE_1172 0 72.54095f
c1143 nSEG_NODE_1173 0 85.6146f
c1144 nSEG_NODE_1174 0 85.6146f
c1145 nSEG_NODE_1175 0 85.6146f
c1146 nSEG_NODE_1176 0 85.6141f
c1147 nSEG_NODE_1177 0 84.7294f
c1148 nSEG_NODE_1178 0 84.72925f
c1149 nSEG_NODE_1179 0 95.825f
c1150 nSEG_NODE_1180 0 95.825f
c1151 nSEG_NODE_1181 0 95.825f
c1152 nSEG_NODE_1182 0 95.82485f
c1153 nSEG_NODE_1183 0 98.5202f
c1154 nSEG_NODE_1184 0 98.5202f
c1155 nSEG_NODE_1185 0 98.5202f
c1156 nSEG_NODE_1186 0 98.5202f
c1157 nSEG_NODE_1187 0 98.5202f
c1158 nSEG_NODE_1188 0 85.3686f
c1159 nSEG_NODE_1189 0 85.3684f
c1160 nSEG_NODE_1190 0 94.56765f
c1161 nSEG_NODE_1191 0 93.20135f
c1162 nSEG_NODE_1192 0 64.88095f
c1163 nSEG_NODE_1193 0 80.7888f
c1164 nSEG_NODE_1194 0 51.81335f
c1165 nSEG_NODE_1195 0 51.81335f
c1166 nSEG_NODE_1196 0 79.8678f
c1167 nSEG_NODE_1197 0 79.8678f
c1168 nSEG_NODE_1198 0 79.86765f
c1169 nSEG_NODE_1199 0 93.5442f
c1170 nSEG_NODE_1200 0 93.5442f
c1171 nSEG_NODE_1201 0 93.54385f
c1172 nSEG_NODE_1202 0 73.1629f
c1173 nSEG_NODE_1203 0 71.41525f
c1174 nSEG_NODE_1204 0 59.04285f
c1175 nSEG_NODE_1205 0 59.04285f
c1176 nSEG_NODE_1206 0 94.1614f
c1177 nSEG_NODE_1207 0 94.16105f
c1178 nSEG_NODE_1208 0 82.028f
c1179 nSEG_NODE_1209 0 82.0278f
c1180 nSEG_NODE_1210 0 67.34445f
c1181 nSEG_NODE_1211 0 65.9533f
c1182 nSEG_NODE_1212 0 89.6235f
c1183 nSEG_NODE_1213 0 58.20715f
c1184 nSEG_NODE_1214 0 88.23235f
c1185 nSEG_NODE_1215 0 54.9457f
c1186 nSEG_NODE_1216 0 54.9457f
c1187 nSEG_NODE_1217 0 98.03415f
c1188 nSEG_NODE_1218 0 55.4137f
c1189 nSEG_NODE_1219 0 52.6635f
c1190 nSEG_NODE_1220 0 52.6635f
c1191 nSEG_NODE_1221 0 83.25605f
c1192 nSEG_NODE_1222 0 55.8346f
c1193 nSEG_NODE_1223 0 84.74205f
c1194 nSEG_NODE_1224 0 57.3206f
c1195 nSEG_NODE_1225 0 57.3206f
c1196 nSEG_NODE_1226 0 85.0974f
c1197 nSEG_NODE_1227 0 85.0974f
c1198 nSEG_NODE_1228 0 85.09685f
c1199 nSEG_NODE_1229 0 89.4126f
c1200 nSEG_NODE_1230 0 89.41255f
c1201 nSEG_NODE_1231 0 67.1298f
c1202 nSEG_NODE_1232 0 54.0881f
c1203 nSEG_NODE_1233 0 53.55405f
c1204 nSEG_NODE_1234 0 53.55405f
c1205 nSEG_NODE_1235 0 71.56675f
c1206 nSEG_NODE_1236 0 55.7256f
c1207 nSEG_NODE_1237 0 55.7256f
c1208 nSEG_NODE_1238 0 78.1187f
c1209 nSEG_NODE_1239 0 78.1187f
c1210 nSEG_NODE_1240 0 82.1599f
c1211 nSEG_NODE_1241 0 79.767f
c1212 nSEG_NODE_1242 0 55.3407f
c1213 nSEG_NODE_1243 0 55.3407f
r0 n574 n353 31.07919375
r1 n584 n289 8.1286
r2 n591 n227 27.39725
r3 n592 n514 44.45515
r4 n593 n515 44.45515
r5 n594 n207 49.37525
r6 n598 n522 42.7356
r7 n599 n528 42.7356
r8 n601 n234 47.20895
r9 n603 n524 46.96865
r10 n605 n525 46.96865
r11 n607 n529 40.18385
r12 n609 n530 40.18385
r13 n612 n512 48.16615
r14 n613 n513 48.16615
r15 n620 n511 46.5662
r16 n621 n517 46.5662
r17 n623 n518 24.28429375
r18 n634 n320 46.728475
r19 n636 n557 0.31315
r20 n645 n550 42.22975
r21 n647 n556 42.22975
r22 n648 n562 31.3926
r23 n649 n563 31.3926
r24 n650 n326 30.63095
r25 n658 n231 27.57155
r26 n660 n558 47.3402
r27 n662 n564 47.3402
r28 n665 n229 39.3808
r29 n666 n567 44.97325
r30 n667 n568 44.97325
r31 n672 n560 39.5068
r32 n673 n561 39.5068
r33 n674 n554 38.7262
r34 n675 n555 38.7262
r35 n683 n543 40.95055
r36 n685 n549 40.95055
r37 n687 n329 24.72845
r38 n688 n294 46.959
r39 n691 n538 42.9152
r40 n693 n544 42.9152
r41 n696 n216 40.20745
r42 n697 n536 42.5784
r43 n698 n537 42.5784
r44 n703 n259 34.3065
r45 n706 n271 37.7772
r46 n716 n199 41.0222
r47 n717 n546 36.8755
r48 n718 n547 36.8755
r49 n720 n193 30.14355
r50 n722 n541 33.50785
r51 n724 n542 33.50785
r52 n731 n300 40.91365
r53 n735 n243 39.3399
r54 n739 n241 42.9262
r55 n741 n426 49.79085
r56 n743 n427 49.79085
r57 n745 n233 46.5958
r58 n746 n393 47.4431
r59 n747 n394 47.4431
r60 n748 n410 41.57975
r61 n749 n411 41.57975
r62 n754 n249 45.4316
r63 n760 n223 48.52785
r64 n761 n244 41.87725
r65 n764 n428 44.10895
r66 n765 n429 44.10895
r67 n767 n266 47.7699
r68 n776 n262 27.011575
r69 n782 n459 36.59815
r70 n783 n460 36.59815
r71 n787 n442 48.81375
r72 n789 n443 48.81375
r73 n793 n235 25.55035
r74 n795 n493 48.5361
r75 n797 n494 48.5361
r76 n798 n475 35.58675
r77 n799 n476 35.58675
r78 n803 n237 23.30305
r79 n810 n479 44.34955
r80 n811 n462 44.34955
r81 n812 n464 43.65265
r82 n813 n481 43.65265
r83 n817 n496 35.524
r84 n819 n497 35.524
r85 n826 n195 29.3476
r86 n837 n482 43.03685
r87 n838 n499 43.03685
r88 n840 n465 35.15125
r89 n842 n466 35.15125
r90 n843 n230 47.884725
r91 n852 n232 29.6607
r92 n854 n484 48.1404
r93 n856 n501 48.1404
r94 n857 n468 38.7146
r95 n858 n485 38.7146
r96 n859 n264 1.85995
r97 n864 n503 40.9509
r98 n866 n504 40.9509
r99 n868 n469 37.53275
r100 n870 n470 37.53275
r101 n875 n200 48.29185
r102 n881 n228 48.25075
r103 n882 n416 44.01005
r104 n883 n417 44.01005
r105 n885 n414 33.5971
r106 n887 n431 33.5971
r107 n888 n432 37.4429
r108 n889 n433 37.4429
r109 n891 n258 47.3147
r110 n898 n214 37.7607
r111 n899 n382 41.0069
r112 n900 n383 41.0069
r113 n906 n450 45.99645
r114 n908 n467 45.99645
r115 n911 n293 5.043
r116 n916 n247 12.95515
r117 n923 n437 43.5045
r118 n924 n438 43.5045
r119 n926 n334 3.3299
r120 n932 n349 19.66
r121 n935 n309 1.3663
r122 n938 n219 49.6614
r123 n939 n422 43.53995
r124 n940 n439 43.53995
r125 n945 n250 28.97545
r126 n951 n226 28.43135
r127 n953 n457 44.73155
r128 n955 n458 44.73155
r129 n957 n280 41.47265
r130 n963 n389 29.10025
r131 n965 n406 29.10025
r132 n973 n385 31.41635
r133 n974 n402 31.41635
r134 n977 n256 33.28665
r135 n982 n202 44.06775
r136 n983 n251 29.29965
r137 n986 n434 37.8954
r138 n987 n435 37.8954
r139 n989 n436 39.3427
r140 n991 n453 39.3427
r141 n995 n212 44.9545
r142 n997 n387 39.78755
r143 n999 n388 39.78755
r144 n1002 n346 12.0411
r145 n1013 n508 40.51235
r146 n1015 n509 40.51235
r147 n1017 n263 15.84115
r148 n1028 n285 2.3929
r149 n1030 n196 43.32445
r150 n1032 n455 36.44255
r151 n1034 n472 36.44255
r152 n1035 n224 48.03655
r153 n1036 n257 36.3875
r154 n1042 n489 43.69165
r155 n1044 n506 43.69165
r156 n570 nSEG_NODE_855 48.9506
r157 nSEG_NODE_855 nSEG_NODE_856 48.9506
r158 nSEG_NODE_856 nSEG_NODE_857 48.9506
r159 nSEG_NODE_857 nSEG_NODE_858 48.9506
r160 nSEG_NODE_858 nSEG_NODE_859 48.9506
r161 nSEG_NODE_859 nSEG_NODE_860 48.9506
r162 nSEG_NODE_860 nSEG_NODE_861 48.9506
r163 nSEG_NODE_861 nSEG_NODE_862 48.9506
r164 nSEG_NODE_862 nSEG_NODE_863 48.9506
r165 nSEG_NODE_863 nSEG_NODE_864 48.9506
r166 nSEG_NODE_864 nSEG_NODE_865 48.9506
r167 nSEG_NODE_865 nSEG_NODE_866 48.9506
r168 nSEG_NODE_866 nSEG_NODE_867 48.9506
r169 nSEG_NODE_867 nSEG_NODE_868 48.9506
r170 nSEG_NODE_868 nSEG_NODE_869 48.9506
r171 nSEG_NODE_869 nSEG_NODE_870 48.9506
r172 nSEG_NODE_870 nSEG_NODE_871 48.9506
r173 nSEG_NODE_871 nSEG_NODE_872 48.9506
r174 nSEG_NODE_872 nSEG_NODE_873 48.9506
r175 nSEG_NODE_873 nSEG_NODE_874 48.9506
r176 nSEG_NODE_874 nSEG_NODE_875 48.9506
r177 nSEG_NODE_875 nSEG_NODE_876 48.9506
r178 nSEG_NODE_876 nSEG_NODE_877 48.9506
r179 nSEG_NODE_877 nSEG_NODE_878 48.9506
r180 nSEG_NODE_878 nSEG_NODE_879 48.9506
r181 nSEG_NODE_879 nSEG_NODE_880 48.9506
r182 nSEG_NODE_880 nSEG_NODE_881 48.9506
r183 nSEG_NODE_881 nSEG_NODE_882 48.9506
r184 nSEG_NODE_882 nSEG_NODE_883 48.9506
r185 nSEG_NODE_883 nSEG_NODE_884 48.9506
r186 nSEG_NODE_884 nSEG_NODE_885 48.9506
r187 nSEG_NODE_885 n378 48.950284375
r188 n571 nSEG_NODE_886 47.6973
r189 nSEG_NODE_886 nSEG_NODE_887 47.6973
r190 nSEG_NODE_887 nSEG_NODE_888 47.6973
r191 nSEG_NODE_888 nSEG_NODE_889 47.6973
r192 nSEG_NODE_889 nSEG_NODE_890 47.6973
r193 nSEG_NODE_890 nSEG_NODE_891 47.6973
r194 nSEG_NODE_891 nSEG_NODE_892 47.6973
r195 nSEG_NODE_892 nSEG_NODE_893 47.6973
r196 nSEG_NODE_893 nSEG_NODE_894 47.6973
r197 nSEG_NODE_894 nSEG_NODE_895 47.6973
r198 nSEG_NODE_895 nSEG_NODE_896 47.6973
r199 nSEG_NODE_896 n376 47.696346875
r200 n572 nSEG_NODE_897 46.9512
r201 nSEG_NODE_897 nSEG_NODE_898 46.9512
r202 nSEG_NODE_898 nSEG_NODE_899 46.9512
r203 nSEG_NODE_899 nSEG_NODE_900 46.9512
r204 nSEG_NODE_900 nSEG_NODE_901 46.9512
r205 nSEG_NODE_901 nSEG_NODE_902 46.9512
r206 nSEG_NODE_902 nSEG_NODE_903 46.9512
r207 nSEG_NODE_903 nSEG_NODE_904 46.9512
r208 nSEG_NODE_904 nSEG_NODE_905 46.9512
r209 nSEG_NODE_905 nSEG_NODE_906 46.9512
r210 nSEG_NODE_906 nSEG_NODE_907 46.9512
r211 nSEG_NODE_907 nSEG_NODE_908 46.9512
r212 nSEG_NODE_908 n377 46.950421875
r213 n575 nSEG_NODE_909 45.9097
r214 nSEG_NODE_909 nSEG_NODE_910 45.9097
r215 nSEG_NODE_910 nSEG_NODE_911 45.9097
r216 nSEG_NODE_911 nSEG_NODE_912 45.9097
r217 nSEG_NODE_912 nSEG_NODE_913 45.9097
r218 nSEG_NODE_913 n332 45.9091
r219 n576 nSEG_NODE_914 43.6108
r220 nSEG_NODE_914 nSEG_NODE_915 43.6108
r221 nSEG_NODE_915 nSEG_NODE_916 43.6108
r222 nSEG_NODE_916 nSEG_NODE_917 43.6108
r223 nSEG_NODE_917 n342 43.61065
r224 n577 nSEG_NODE_918 39.2831
r225 nSEG_NODE_918 nSEG_NODE_919 39.2831
r226 nSEG_NODE_919 n269 39.28285
r227 n578 nSEG_NODE_920 26.3563
r228 nSEG_NODE_920 n322 26.35625
r229 n579 nSEG_NODE_921 32.3828
r230 nSEG_NODE_921 n292 32.3827
r231 n580 nSEG_NODE_922 33.8417
r232 nSEG_NODE_922 n298 33.84145
r233 n581 nSEG_NODE_923 34.653
r234 nSEG_NODE_923 n521 34.65275
r235 n582 nSEG_NODE_924 34.6529
r236 nSEG_NODE_924 n527 34.65285
r237 n583 nSEG_NODE_925 36.1118
r238 nSEG_NODE_925 n526 36.1116
r239 n586 nSEG_NODE_926 32.0474
r240 nSEG_NODE_926 n519 32.0474
r241 n588 nSEG_NODE_927 32.0474
r242 nSEG_NODE_927 n520 32.0474
r243 n590 nSEG_NODE_928 35.9262
r244 nSEG_NODE_928 n498 35.9262
r245 n596 nSEG_NODE_929 40.4295
r246 nSEG_NODE_929 n305 40.4292
r247 n597 nSEG_NODE_930 44.1004
r248 nSEG_NODE_930 nSEG_NODE_931 44.1004
r249 nSEG_NODE_931 n217 44.0999
r250 n600 nSEG_NODE_932 47.0889
r251 nSEG_NODE_932 n523 47.0887
r252 n611 nSEG_NODE_933 34.7376
r253 nSEG_NODE_933 nSEG_NODE_934 34.7376
r254 nSEG_NODE_934 n236 34.73735625
r255 n615 nSEG_NODE_935 44.0763
r256 nSEG_NODE_935 nSEG_NODE_936 44.0763
r257 nSEG_NODE_936 nSEG_NODE_937 44.0763
r258 nSEG_NODE_937 n297 44.07610625
r259 n616 nSEG_NODE_938 34.4226
r260 nSEG_NODE_938 n239 34.4223
r261 n617 nSEG_NODE_939 31.8163
r262 nSEG_NODE_939 n248 31.81625
r263 n618 nSEG_NODE_940 25.8893
r264 nSEG_NODE_940 n510 25.88925
r265 n619 nSEG_NODE_941 25.8893
r266 nSEG_NODE_941 n516 25.88925
r267 n625 nSEG_NODE_942 48.293
r268 nSEG_NODE_942 nSEG_NODE_943 48.293
r269 nSEG_NODE_943 nSEG_NODE_944 48.293
r270 nSEG_NODE_944 nSEG_NODE_945 48.293
r271 nSEG_NODE_945 nSEG_NODE_946 48.293
r272 nSEG_NODE_946 nSEG_NODE_947 48.293
r273 nSEG_NODE_947 nSEG_NODE_948 48.293
r274 nSEG_NODE_948 nSEG_NODE_949 48.293
r275 nSEG_NODE_949 nSEG_NODE_950 48.293
r276 nSEG_NODE_950 nSEG_NODE_951 48.293
r277 nSEG_NODE_951 nSEG_NODE_952 48.293
r278 nSEG_NODE_952 n370 48.29121875
r279 n626 nSEG_NODE_953 47.6753
r280 nSEG_NODE_953 nSEG_NODE_954 47.6753
r281 nSEG_NODE_954 nSEG_NODE_955 47.6753
r282 nSEG_NODE_955 nSEG_NODE_956 47.6753
r283 nSEG_NODE_956 nSEG_NODE_957 47.6753
r284 nSEG_NODE_957 nSEG_NODE_958 47.6753
r285 nSEG_NODE_958 nSEG_NODE_959 47.6753
r286 nSEG_NODE_959 nSEG_NODE_960 47.6753
r287 nSEG_NODE_960 nSEG_NODE_961 47.6753
r288 nSEG_NODE_961 nSEG_NODE_962 47.6753
r289 nSEG_NODE_962 nSEG_NODE_963 47.6753
r290 nSEG_NODE_963 n375 47.67504375
r291 n627 nSEG_NODE_964 42.7238
r292 nSEG_NODE_964 nSEG_NODE_965 42.7238
r293 nSEG_NODE_965 nSEG_NODE_966 42.7238
r294 nSEG_NODE_966 nSEG_NODE_967 42.7238
r295 nSEG_NODE_967 n367 42.72345
r296 n628 nSEG_NODE_968 40.8256
r297 nSEG_NODE_968 n371 40.82545
r298 n629 nSEG_NODE_969 48.6988
r299 nSEG_NODE_969 nSEG_NODE_970 48.6988
r300 nSEG_NODE_970 n355 48.69875
r301 n630 nSEG_NODE_971 46.7866
r302 nSEG_NODE_971 nSEG_NODE_972 46.7866
r303 nSEG_NODE_972 nSEG_NODE_973 46.7866
r304 nSEG_NODE_973 nSEG_NODE_974 46.7866
r305 nSEG_NODE_974 n359 46.786175
r306 n631 nSEG_NODE_975 43.1698
r307 nSEG_NODE_975 n191 43.169675
r308 n633 nSEG_NODE_976 36.8196
r309 nSEG_NODE_976 nSEG_NODE_977 36.8196
r310 nSEG_NODE_977 n215 36.819425
r311 n638 nSEG_NODE_978 42.3214
r312 nSEG_NODE_978 nSEG_NODE_979 42.3214
r313 nSEG_NODE_979 nSEG_NODE_980 42.3214
r314 nSEG_NODE_980 nSEG_NODE_981 42.3214
r315 nSEG_NODE_981 n569 42.32105
r316 n639 nSEG_NODE_982 40.3
r317 nSEG_NODE_982 nSEG_NODE_983 40.3
r318 nSEG_NODE_983 nSEG_NODE_984 40.3
r319 nSEG_NODE_984 n242 40.2993
r320 n641 nSEG_NODE_985 25.2037
r321 nSEG_NODE_985 n545 25.20365
r322 n643 nSEG_NODE_986 25.2037
r323 nSEG_NODE_986 n551 25.20365
r324 n652 nSEG_NODE_987 42.2657
r325 nSEG_NODE_987 nSEG_NODE_988 42.2657
r326 nSEG_NODE_988 nSEG_NODE_989 42.2657
r327 nSEG_NODE_989 nSEG_NODE_990 42.2657
r328 nSEG_NODE_990 n299 42.265
r329 n653 nSEG_NODE_991 37.782
r330 nSEG_NODE_991 nSEG_NODE_992 37.782
r331 nSEG_NODE_992 nSEG_NODE_993 37.782
r332 nSEG_NODE_993 n345 37.78195
r333 n655 nSEG_NODE_994 48.1847
r334 nSEG_NODE_994 nSEG_NODE_995 48.1847
r335 nSEG_NODE_995 n552 48.1845
r336 n656 nSEG_NODE_996 34.8211
r337 nSEG_NODE_996 n268 34.82105
r338 n657 nSEG_NODE_997 37.456
r339 nSEG_NODE_997 n565 37.45575
r340 n664 nSEG_NODE_998 42.1771
r341 nSEG_NODE_998 n566 42.17695
r342 n668 nSEG_NODE_999 49.6442
r343 nSEG_NODE_999 n260 49.644
r344 n669 nSEG_NODE_1000 30.0258
r345 nSEG_NODE_1000 n261 30.02575
r346 n670 nSEG_NODE_1001 27.9794
r347 nSEG_NODE_1001 n203 27.97925
r348 n671 nSEG_NODE_1002 27.5891
r349 nSEG_NODE_1002 n206 27.58895
r350 n677 nSEG_NODE_1003 27.7241
r351 nSEG_NODE_1003 n553 27.7241
r352 n679 nSEG_NODE_1004 27.7242
r353 nSEG_NODE_1004 n559 27.724
r354 n681 nSEG_NODE_1005 33.0159
r355 nSEG_NODE_1005 n209 33.01575
r356 n689 nSEG_NODE_1006 43.4149
r357 nSEG_NODE_1006 n218 43.41475
r358 n695 nSEG_NODE_1007 41.393
r359 nSEG_NODE_1007 n531 41.39285
r360 n699 nSEG_NODE_1008 44.7927
r361 nSEG_NODE_1008 nSEG_NODE_1009 44.7927
r362 nSEG_NODE_1009 nSEG_NODE_1010 44.7927
r363 nSEG_NODE_1010 nSEG_NODE_1011 44.7927
r364 nSEG_NODE_1011 n314 44.7925
r365 n700 nSEG_NODE_1012 45.6692
r366 nSEG_NODE_1012 nSEG_NODE_1013 45.6692
r367 nSEG_NODE_1013 nSEG_NODE_1014 45.6692
r368 nSEG_NODE_1014 nSEG_NODE_1015 45.6692
r369 nSEG_NODE_1015 nSEG_NODE_1016 45.6692
r370 nSEG_NODE_1016 n310 45.6689
r371 n702 nSEG_NODE_1017 44.9217
r372 nSEG_NODE_1017 n532 44.9216
r373 n704 nSEG_NODE_1018 27.7685
r374 nSEG_NODE_1018 n533 27.7683
r375 n705 nSEG_NODE_1019 27.7684
r376 nSEG_NODE_1019 n539 27.7684
r377 n708 nSEG_NODE_1020 33.4879
r378 nSEG_NODE_1020 nSEG_NODE_1021 33.4879
r379 nSEG_NODE_1021 n288 33.4877
r380 n709 nSEG_NODE_1022 35.6453
r381 nSEG_NODE_1022 nSEG_NODE_1023 35.6453
r382 nSEG_NODE_1023 n306 35.64495
r383 n711 nSEG_NODE_1024 35.7129
r384 nSEG_NODE_1024 n534 35.71275
r385 n713 nSEG_NODE_1025 35.7129
r386 nSEG_NODE_1025 n540 35.71275
r387 n715 nSEG_NODE_1026 38.9489
r388 nSEG_NODE_1026 n548 38.9488
r389 n719 nSEG_NODE_1027 31.8257
r390 nSEG_NODE_1027 n535 31.8257
r391 n726 nSEG_NODE_1028 46.6748
r392 nSEG_NODE_1028 nSEG_NODE_1029 46.6748
r393 nSEG_NODE_1029 n344 46.6746375
r394 n727 nSEG_NODE_1030 32.6589
r395 nSEG_NODE_1030 n253 32.65865
r396 n729 nSEG_NODE_1031 47.5762
r397 nSEG_NODE_1031 nSEG_NODE_1032 47.5762
r398 nSEG_NODE_1032 n296 47.5762
r399 n730 nSEG_NODE_1033 35.0375
r400 nSEG_NODE_1033 nSEG_NODE_1034 35.0375
r401 nSEG_NODE_1034 n337 35.03715
r402 n732 nSEG_NODE_1035 43.4446
r403 nSEG_NODE_1035 nSEG_NODE_1036 43.4446
r404 nSEG_NODE_1036 n392 43.4443
r405 n734 nSEG_NODE_1037 44.71
r406 nSEG_NODE_1037 n409 44.70985
r407 n736 nSEG_NODE_1038 25.04
r408 nSEG_NODE_1038 n391 25.03995
r409 n737 nSEG_NODE_1039 25.04
r410 nSEG_NODE_1039 n408 25.03995
r411 n738 nSEG_NODE_1040 46.3586
r412 nSEG_NODE_1040 n444 46.35845
r413 n744 nSEG_NODE_1041 26.2297
r414 nSEG_NODE_1041 n213 26.22945
r415 n750 nSEG_NODE_1042 45.2586
r416 nSEG_NODE_1042 nSEG_NODE_1043 45.2586
r417 nSEG_NODE_1043 nSEG_NODE_1044 45.2586
r418 nSEG_NODE_1044 nSEG_NODE_1045 45.2586
r419 nSEG_NODE_1045 nSEG_NODE_1046 45.2586
r420 nSEG_NODE_1046 n364 45.2580875
r421 n751 nSEG_NODE_1047 46.5324
r422 nSEG_NODE_1047 nSEG_NODE_1048 46.5324
r423 nSEG_NODE_1048 nSEG_NODE_1049 46.5324
r424 nSEG_NODE_1049 nSEG_NODE_1050 46.5324
r425 nSEG_NODE_1050 n356 46.5318375
r426 n752 nSEG_NODE_1051 49.1865
r427 nSEG_NODE_1051 nSEG_NODE_1052 49.1865
r428 nSEG_NODE_1052 n275 49.18625
r429 n753 nSEG_NODE_1053 38.6912
r430 nSEG_NODE_1053 nSEG_NODE_1054 38.6912
r431 nSEG_NODE_1054 n313 38.6911
r432 n755 nSEG_NODE_1055 38.2915
r433 nSEG_NODE_1055 n284 38.2914
r434 n757 nSEG_NODE_1056 30.7428
r435 nSEG_NODE_1056 n430 30.7427
r436 n759 nSEG_NODE_1057 30.7428
r437 nSEG_NODE_1057 n447 30.7427
r438 n762 nSEG_NODE_1058 25.3799
r439 nSEG_NODE_1058 n445 25.37965
r440 n763 nSEG_NODE_1059 25.3798
r441 nSEG_NODE_1059 n446 25.37975
r442 n766 nSEG_NODE_1060 28.0571
r443 nSEG_NODE_1060 n246 28.05695
r444 n769 nSEG_NODE_1061 29.4064
r445 nSEG_NODE_1061 n395 29.40635
r446 n771 nSEG_NODE_1062 29.4064
r447 nSEG_NODE_1062 n396 29.40635
r448 n773 nSEG_NODE_1063 25.2343
r449 nSEG_NODE_1063 n412 25.2343
r450 n775 nSEG_NODE_1064 25.2343
r451 nSEG_NODE_1064 n413 25.2343
r452 n778 nSEG_NODE_1065 45.0548
r453 nSEG_NODE_1065 n325 45.054575
r454 n779 nSEG_NODE_1066 40.3599
r455 nSEG_NODE_1066 nSEG_NODE_1067 40.3599
r456 nSEG_NODE_1067 nSEG_NODE_1068 40.3599
r457 nSEG_NODE_1068 n343 40.359825
r458 n781 nSEG_NODE_1069 27.222
r459 nSEG_NODE_1069 n197 27.2219
r460 n784 nSEG_NODE_1070 26.4583
r461 nSEG_NODE_1070 n328 26.45815
r462 n785 nSEG_NODE_1071 46.8459
r463 nSEG_NODE_1071 nSEG_NODE_1072 46.8459
r464 nSEG_NODE_1072 n245 46.8454
r465 n790 nSEG_NODE_1073 33.616
r466 nSEG_NODE_1073 nSEG_NODE_1074 33.616
r467 nSEG_NODE_1074 n201 33.61575
r468 n791 nSEG_NODE_1075 31.1741
r469 nSEG_NODE_1075 n282 31.17395
r470 n792 nSEG_NODE_1076 37.0433
r471 nSEG_NODE_1076 n477 37.04315
r472 n800 nSEG_NODE_1077 40.591
r473 nSEG_NODE_1077 nSEG_NODE_1078 40.591
r474 nSEG_NODE_1078 n308 40.5906
r475 n801 nSEG_NODE_1079 34.3968
r476 nSEG_NODE_1079 nSEG_NODE_1080 34.3968
r477 nSEG_NODE_1080 n318 34.39665
r478 n805 nSEG_NODE_1081 27.4296
r479 nSEG_NODE_1081 n480 27.42945
r480 n807 nSEG_NODE_1082 27.4296
r481 nSEG_NODE_1082 n463 27.42945
r482 n808 nSEG_NODE_1083 47.4291
r483 nSEG_NODE_1083 n222 47.42895
r484 n809 nSEG_NODE_1084 47.0806
r485 nSEG_NODE_1084 n225 47.08055
r486 n814 nSEG_NODE_1085 44.8771
r487 nSEG_NODE_1085 n495 44.87695
r488 n815 nSEG_NODE_1086 27.1151
r489 nSEG_NODE_1086 n198 27.11495
r490 n820 nSEG_NODE_1087 26.3513
r491 nSEG_NODE_1087 n461 26.35115
r492 n821 nSEG_NODE_1088 26.3513
r493 nSEG_NODE_1088 n478 26.35115
r494 n822 nSEG_NODE_1089 40.1464
r495 nSEG_NODE_1089 nSEG_NODE_1090 40.1464
r496 nSEG_NODE_1090 nSEG_NODE_1091 40.1464
r497 nSEG_NODE_1091 nSEG_NODE_1092 40.1464
r498 nSEG_NODE_1092 n373 40.1460625
r499 n823 nSEG_NODE_1093 49.205
r500 nSEG_NODE_1093 nSEG_NODE_1094 49.205
r501 nSEG_NODE_1094 nSEG_NODE_1095 49.205
r502 nSEG_NODE_1095 nSEG_NODE_1096 49.205
r503 nSEG_NODE_1096 nSEG_NODE_1097 49.205
r504 nSEG_NODE_1097 n374 49.2049125
r505 n825 nSEG_NODE_1098 37.945
r506 nSEG_NODE_1098 nSEG_NODE_1099 37.945
r507 nSEG_NODE_1099 nSEG_NODE_1100 37.945
r508 nSEG_NODE_1100 n321 37.944375
r509 n828 nSEG_NODE_1101 40.0142
r510 nSEG_NODE_1101 nSEG_NODE_1102 40.0142
r511 nSEG_NODE_1102 n286 40.01405
r512 n829 nSEG_NODE_1103 47.414
r513 nSEG_NODE_1103 nSEG_NODE_1104 47.414
r514 nSEG_NODE_1104 n287 47.4137
r515 n830 nSEG_NODE_1105 31.7632
r516 nSEG_NODE_1105 n448 31.76305
r517 n831 nSEG_NODE_1106 31.7632
r518 nSEG_NODE_1106 n449 31.76305
r519 n832 nSEG_NODE_1107 29.5115
r520 nSEG_NODE_1107 n483 29.5113
r521 n835 nSEG_NODE_1108 37.4761
r522 nSEG_NODE_1108 nSEG_NODE_1109 37.4761
r523 nSEG_NODE_1109 n500 37.476
r524 n836 nSEG_NODE_1110 34.6957
r525 nSEG_NODE_1110 n221 34.69565
r526 n845 nSEG_NODE_1111 44.6639
r527 nSEG_NODE_1111 nSEG_NODE_1112 44.6639
r528 nSEG_NODE_1112 nSEG_NODE_1113 44.6639
r529 nSEG_NODE_1113 nSEG_NODE_1114 44.6639
r530 nSEG_NODE_1114 nSEG_NODE_1115 44.6639
r531 nSEG_NODE_1115 nSEG_NODE_1116 44.6639
r532 nSEG_NODE_1116 n340 44.663575
r533 n846 nSEG_NODE_1117 47.469
r534 nSEG_NODE_1117 nSEG_NODE_1118 47.469
r535 nSEG_NODE_1118 nSEG_NODE_1119 47.469
r536 nSEG_NODE_1119 nSEG_NODE_1120 47.469
r537 nSEG_NODE_1120 nSEG_NODE_1121 47.469
r538 nSEG_NODE_1121 nSEG_NODE_1122 47.469
r539 nSEG_NODE_1122 n341 47.4684
r540 n847 nSEG_NODE_1123 44.0317
r541 nSEG_NODE_1123 nSEG_NODE_1124 44.0317
r542 nSEG_NODE_1124 n315 44.031425
r543 n848 nSEG_NODE_1125 33.5325
r544 nSEG_NODE_1125 nSEG_NODE_1126 33.5325
r545 nSEG_NODE_1126 n327 33.532425
r546 n849 nSEG_NODE_1127 47.5018
r547 nSEG_NODE_1127 n205 47.5017
r548 n850 nSEG_NODE_1128 27.9586
r549 nSEG_NODE_1128 n270 27.9584
r550 n851 nSEG_NODE_1129 38.9006
r551 nSEG_NODE_1129 n502 38.9005
r552 n861 nSEG_NODE_1130 35.4028
r553 nSEG_NODE_1130 nSEG_NODE_1131 35.4028
r554 nSEG_NODE_1131 n204 35.4023
r555 n862 nSEG_NODE_1132 34.2633
r556 nSEG_NODE_1132 nSEG_NODE_1133 34.2633
r557 nSEG_NODE_1133 n211 34.26315
r558 n871 nSEG_NODE_1134 29.4205
r559 nSEG_NODE_1134 n486 29.4203
r560 n872 nSEG_NODE_1135 29.4205
r561 nSEG_NODE_1135 n487 29.4203
r562 n873 nSEG_NODE_1136 37.765
r563 nSEG_NODE_1136 nSEG_NODE_1137 37.765
r564 nSEG_NODE_1137 n331 37.76485
r565 n874 nSEG_NODE_1138 39.0063
r566 nSEG_NODE_1138 nSEG_NODE_1139 39.0063
r567 nSEG_NODE_1139 n338 39.0061
r568 n877 nSEG_NODE_1140 38.6332
r569 nSEG_NODE_1140 nSEG_NODE_1141 38.6332
r570 nSEG_NODE_1141 nSEG_NODE_1142 38.6332
r571 nSEG_NODE_1142 n194 38.63305
r572 n878 nSEG_NODE_1143 47.9345
r573 nSEG_NODE_1143 n301 47.93445
r574 n880 nSEG_NODE_1144 46.1304
r575 nSEG_NODE_1144 n415 46.1304
r576 n892 nSEG_NODE_1145 26.8088
r577 nSEG_NODE_1145 n381 26.8088
r578 n893 nSEG_NODE_1146 26.8088
r579 nSEG_NODE_1146 n398 26.8088
r580 n894 nSEG_NODE_1147 43.0211
r581 nSEG_NODE_1147 nSEG_NODE_1148 43.0211
r582 nSEG_NODE_1148 n252 43.0209
r583 n895 nSEG_NODE_1149 33.8709
r584 nSEG_NODE_1149 nSEG_NODE_1150 33.8709
r585 nSEG_NODE_1150 n273 33.8705
r586 n897 nSEG_NODE_1151 39.3838
r587 nSEG_NODE_1151 n399 39.3838
r588 n902 nSEG_NODE_1152 25.6585
r589 nSEG_NODE_1152 n380 25.6583
r590 n904 nSEG_NODE_1153 25.6584
r591 nSEG_NODE_1153 n397 25.6584
r592 n909 nSEG_NODE_1154 44.4289
r593 nSEG_NODE_1154 nSEG_NODE_1155 44.4289
r594 nSEG_NODE_1155 nSEG_NODE_1156 44.4289
r595 nSEG_NODE_1156 nSEG_NODE_1157 44.4289
r596 nSEG_NODE_1157 n272 44.4285
r597 n913 nSEG_NODE_1158 48.7878
r598 nSEG_NODE_1158 nSEG_NODE_1159 48.7878
r599 nSEG_NODE_1159 nSEG_NODE_1160 48.7878
r600 nSEG_NODE_1160 nSEG_NODE_1161 48.7878
r601 nSEG_NODE_1161 nSEG_NODE_1162 48.7878
r602 nSEG_NODE_1162 nSEG_NODE_1163 48.7878
r603 nSEG_NODE_1163 nSEG_NODE_1164 48.7878
r604 nSEG_NODE_1164 n358 48.7875
r605 n914 nSEG_NODE_1165 46.9338
r606 nSEG_NODE_1165 nSEG_NODE_1166 46.9338
r607 nSEG_NODE_1166 nSEG_NODE_1167 46.9338
r608 nSEG_NODE_1167 nSEG_NODE_1168 46.9338
r609 nSEG_NODE_1168 n365 46.93355
r610 n918 nSEG_NODE_1169 25.7155
r611 nSEG_NODE_1169 n420 25.7154
r612 n920 nSEG_NODE_1170 25.7155
r613 nSEG_NODE_1170 n421 25.7154
r614 n922 nSEG_NODE_1171 36.2705
r615 nSEG_NODE_1171 nSEG_NODE_1172 36.2705
r616 nSEG_NODE_1172 n220 36.27045
r617 n925 nSEG_NODE_1173 42.8073
r618 nSEG_NODE_1173 nSEG_NODE_1174 42.8073
r619 nSEG_NODE_1174 nSEG_NODE_1175 42.8073
r620 nSEG_NODE_1175 nSEG_NODE_1176 42.8073
r621 nSEG_NODE_1176 n319 42.8068
r622 n928 nSEG_NODE_1177 42.3647
r623 nSEG_NODE_1177 nSEG_NODE_1178 42.3647
r624 nSEG_NODE_1178 n419 42.36455
r625 n930 nSEG_NODE_1179 47.9125
r626 nSEG_NODE_1179 nSEG_NODE_1180 47.9125
r627 nSEG_NODE_1180 nSEG_NODE_1181 47.9125
r628 nSEG_NODE_1181 nSEG_NODE_1182 47.9125
r629 nSEG_NODE_1182 n361 47.91235
r630 n931 nSEG_NODE_1183 49.2601
r631 nSEG_NODE_1183 nSEG_NODE_1184 49.2601
r632 nSEG_NODE_1184 nSEG_NODE_1185 49.2601
r633 nSEG_NODE_1185 nSEG_NODE_1186 49.2601
r634 nSEG_NODE_1186 nSEG_NODE_1187 49.2601
r635 nSEG_NODE_1187 n354 49.2601
r636 n933 nSEG_NODE_1188 42.6843
r637 nSEG_NODE_1188 nSEG_NODE_1189 42.6843
r638 nSEG_NODE_1189 n312 42.6841
r639 n934 nSEG_NODE_1190 47.2839
r640 nSEG_NODE_1190 n405 47.28375
r641 n937 nSEG_NODE_1191 46.6008
r642 nSEG_NODE_1191 n423 46.60055
r643 n942 nSEG_NODE_1192 32.4405
r644 nSEG_NODE_1192 n278 32.44045
r645 n944 nSEG_NODE_1193 40.3944
r646 nSEG_NODE_1193 n425 40.3944
r647 n946 nSEG_NODE_1194 25.9068
r648 nSEG_NODE_1194 n424 25.90655
r649 n947 nSEG_NODE_1195 25.9067
r650 nSEG_NODE_1195 n441 25.90665
r651 n948 nSEG_NODE_1196 39.9339
r652 nSEG_NODE_1196 nSEG_NODE_1197 39.9339
r653 nSEG_NODE_1197 nSEG_NODE_1198 39.9339
r654 nSEG_NODE_1198 n350 39.93375
r655 n949 nSEG_NODE_1199 46.7721
r656 nSEG_NODE_1199 nSEG_NODE_1200 46.7721
r657 nSEG_NODE_1200 nSEG_NODE_1201 46.7721
r658 nSEG_NODE_1201 n283 46.77175
r659 n950 nSEG_NODE_1202 36.5816
r660 nSEG_NODE_1202 n440 36.5813
r661 n956 nSEG_NODE_1203 35.7077
r662 nSEG_NODE_1203 n190 35.70755
r663 n959 nSEG_NODE_1204 29.5215
r664 nSEG_NODE_1204 n390 29.52135
r665 n961 nSEG_NODE_1205 29.5215
r666 nSEG_NODE_1205 n407 29.52135
r667 n966 nSEG_NODE_1206 47.0807
r668 nSEG_NODE_1206 nSEG_NODE_1207 47.0807
r669 nSEG_NODE_1207 n311 47.08035
r670 n967 nSEG_NODE_1208 41.014
r671 nSEG_NODE_1208 nSEG_NODE_1209 41.014
r672 nSEG_NODE_1209 n333 41.0138
r673 n968 nSEG_NODE_1210 33.6723
r674 nSEG_NODE_1210 n279 33.67215
r675 n969 nSEG_NODE_1211 32.9767
r676 nSEG_NODE_1211 n316 32.9766
r677 n971 nSEG_NODE_1212 44.8119
r678 nSEG_NODE_1212 n384 44.8116
r679 n972 nSEG_NODE_1213 29.1036
r680 nSEG_NODE_1213 n192 29.10355
r681 n976 nSEG_NODE_1214 44.1162
r682 nSEG_NODE_1214 n418 44.11615
r683 n978 nSEG_NODE_1215 27.473
r684 nSEG_NODE_1215 n400 27.4727
r685 n979 nSEG_NODE_1216 27.4729
r686 nSEG_NODE_1216 n401 27.4728
r687 n980 nSEG_NODE_1217 49.0171
r688 nSEG_NODE_1217 n208 49.01705
r689 n981 nSEG_NODE_1218 27.707
r690 nSEG_NODE_1218 n254 27.7067
r691 n984 nSEG_NODE_1219 26.3318
r692 nSEG_NODE_1219 n451 26.3317
r693 n985 nSEG_NODE_1220 26.3318
r694 nSEG_NODE_1220 n452 26.3317
r695 n992 nSEG_NODE_1221 41.6281
r696 nSEG_NODE_1221 n274 41.62795
r697 n993 nSEG_NODE_1222 27.9173
r698 nSEG_NODE_1222 n295 27.9173
r699 n994 nSEG_NODE_1223 42.3711
r700 nSEG_NODE_1223 n386 42.37095
r701 n1000 nSEG_NODE_1224 28.6603
r702 nSEG_NODE_1224 n403 28.6603
r703 n1001 nSEG_NODE_1225 28.6603
r704 nSEG_NODE_1225 n404 28.6603
r705 n1004 nSEG_NODE_1226 42.5487
r706 nSEG_NODE_1226 nSEG_NODE_1227 42.5487
r707 nSEG_NODE_1227 nSEG_NODE_1228 42.5487
r708 nSEG_NODE_1228 n267 42.54815
r709 n1005 nSEG_NODE_1229 44.7063
r710 nSEG_NODE_1229 nSEG_NODE_1230 44.7063
r711 nSEG_NODE_1230 n303 44.70625
r712 n1006 nSEG_NODE_1231 33.5649
r713 nSEG_NODE_1231 n210 33.5649
r714 n1007 nSEG_NODE_1232 27.0441
r715 nSEG_NODE_1232 n255 27.044
r716 n1009 nSEG_NODE_1233 26.7771
r717 nSEG_NODE_1233 n491 26.77695
r718 n1011 nSEG_NODE_1234 26.7771
r719 nSEG_NODE_1234 n492 26.77695
r720 n1016 nSEG_NODE_1235 35.7834
r721 nSEG_NODE_1235 n456 35.78335
r722 n1019 nSEG_NODE_1236 27.8628
r723 nSEG_NODE_1236 n473 27.8628
r724 n1021 nSEG_NODE_1237 27.8628
r725 nSEG_NODE_1237 n474 27.8628
r726 n1023 nSEG_NODE_1238 39.0594
r727 nSEG_NODE_1238 n507 39.0593
r728 n1025 nSEG_NODE_1239 39.0594
r729 nSEG_NODE_1239 n490 39.0593
r730 n1027 nSEG_NODE_1240 41.08
r731 nSEG_NODE_1240 n454 41.0799
r732 n1029 nSEG_NODE_1241 39.8836
r733 nSEG_NODE_1241 n471 39.8834
r734 n1038 nSEG_NODE_1242 27.6704
r735 nSEG_NODE_1242 n488 27.6703
r736 n1040 nSEG_NODE_1243 27.6704
r737 nSEG_NODE_1243 n505 27.6703
x0 gin n0 vdd inv0
x1 n0 n570 vdd inv0
x2 n378 n571 vdd inv0
x3 n378 n572 vdd inv0
x4 n377 n369 vdd inv0
x5 n377 n574 vdd inv0
x6 n353 n575 vdd inv0
x7 n353 n576 vdd inv0
x8 n342 n577 vdd inv0
x9 n342 n578 vdd inv0
x10 n322 n579 vdd inv0
x11 n322 n580 vdd inv0
x12 n298 n581 vdd inv0
x13 n298 n582 vdd inv0
x14 n292 n583 vdd inv0
x15 n292 n584 vdd inv0
x16 n289 n585 vdd inv0
x17 n585 n586 vdd inv0
x18 n289 n587 vdd inv0
x19 n587 n588 vdd inv0
x20 n269 n589 vdd inv0
x21 n589 n590 vdd inv0
x22 n269 n591 vdd inv0
x23 n227 n592 vdd inv0
x24 n227 n593 vdd inv0
x25 n332 n594 vdd inv0
x26 n332 n324 vdd inv0
x27 n324 n596 vdd inv0
x28 n324 n597 vdd inv0
x29 n217 n598 vdd inv0
x30 n217 n599 vdd inv0
x31 n305 n600 vdd inv0
x32 n305 n601 vdd inv0
x33 n234 n602 vdd inv0
x34 n602 n603 vdd inv0
x35 n234 n604 vdd inv0
x36 n604 n605 vdd inv0
x37 n207 n606 vdd inv0
x38 n606 n607 vdd inv0
x39 n207 n608 vdd inv0
x40 n608 n609 vdd inv0
x41 n369 n352 vdd inv0
x42 n369 n611 vdd inv0
x43 n236 n612 vdd inv0
x44 n236 n613 vdd inv0
x45 n352 n291 vdd inv0
x46 n352 n615 vdd inv0
x47 n297 n616 vdd inv0
x48 n297 n617 vdd inv0
x49 n248 n618 vdd inv0
x50 n248 n619 vdd inv0
x51 n239 n620 vdd inv0
x52 n239 n621 vdd inv0
x53 n291 n622 vdd inv0
x54 n622 n623 vdd inv0
x55 n291 n368 vdd inv0
x56 n368 n625 vdd inv0
x57 n368 n626 vdd inv0
x58 n375 n627 vdd inv0
x59 n375 n628 vdd inv0
x60 n371 n629 vdd inv0
x61 n371 n630 vdd inv0
x62 n359 n631 vdd inv0
x63 n359 n323 vdd inv0
x64 n323 n633 vdd inv0
x65 n323 n634 vdd inv0
x66 n320 n635 vdd inv0
x67 n635 n636 vdd inv0
x68 n320 n290 vdd inv0
x69 n290 n638 vdd inv0
x70 n290 n639 vdd inv0
x71 n242 n640 vdd inv0
x72 n640 n641 vdd inv0
x73 n242 n642 vdd inv0
x74 n642 n643 vdd inv0
x75 n215 n644 vdd inv0
x76 n644 n645 vdd inv0
x77 n215 n646 vdd inv0
x78 n646 n647 vdd inv0
x79 n191 n648 vdd inv0
x80 n191 n649 vdd inv0
x81 n355 n650 vdd inv0
x82 n355 n351 vdd inv0
x83 n351 n652 vdd inv0
x84 n351 n653 vdd inv0
x85 n345 n654 vdd inv0
x86 n654 n655 vdd inv0
x87 n345 n656 vdd inv0
x88 n268 n657 vdd inv0
x89 n268 n658 vdd inv0
x90 n231 n659 vdd inv0
x91 n659 n660 vdd inv0
x92 n231 n661 vdd inv0
x93 n661 n662 vdd inv0
x94 n299 n663 vdd inv0
x95 n663 n664 vdd inv0
x96 n299 n665 vdd inv0
x97 n229 n666 vdd inv0
x98 n229 n667 vdd inv0
x99 n326 n668 vdd inv0
x100 n326 n669 vdd inv0
x101 n261 n670 vdd inv0
x102 n261 n671 vdd inv0
x103 n206 n672 vdd inv0
x104 n206 n673 vdd inv0
x105 n203 n674 vdd inv0
x106 n203 n675 vdd inv0
x107 n260 n676 vdd inv0
x108 n676 n677 vdd inv0
x109 n260 n678 vdd inv0
x110 n678 n679 vdd inv0
x111 n367 n335 vdd inv0
x112 n367 n681 vdd inv0
x113 n209 n682 vdd inv0
x114 n682 n683 vdd inv0
x115 n209 n684 vdd inv0
x116 n684 n685 vdd inv0
x117 n335 n357 vdd inv0
x118 n335 n687 vdd inv0
x119 n329 n688 vdd inv0
x120 n329 n689 vdd inv0
x121 n218 n690 vdd inv0
x122 n690 n691 vdd inv0
x123 n218 n692 vdd inv0
x124 n692 n693 vdd inv0
x125 n294 n694 vdd inv0
x126 n694 n695 vdd inv0
x127 n294 n696 vdd inv0
x128 n216 n697 vdd inv0
x129 n216 n698 vdd inv0
x130 n357 n699 vdd inv0
x131 n357 n700 vdd inv0
x132 n310 n701 vdd inv0
x133 n701 n702 vdd inv0
x134 n310 n703 vdd inv0
x135 n259 n704 vdd inv0
x136 n259 n705 vdd inv0
x137 n314 n706 vdd inv0
x138 n314 n307 vdd inv0
x139 n307 n708 vdd inv0
x140 n307 n709 vdd inv0
x141 n306 n710 vdd inv0
x142 n710 n711 vdd inv0
x143 n306 n712 vdd inv0
x144 n712 n713 vdd inv0
x145 n288 n714 vdd inv0
x146 n714 n715 vdd inv0
x147 n288 n716 vdd inv0
x148 n199 n717 vdd inv0
x149 n199 n718 vdd inv0
x150 n271 n719 vdd inv0
x151 n271 n720 vdd inv0
x152 n193 n721 vdd inv0
x153 n721 n722 vdd inv0
x154 n193 n723 vdd inv0
x155 n723 n724 vdd inv0
x156 n370 n362 vdd inv0
x157 n370 n726 vdd inv0
x158 n344 n727 vdd inv0
x159 n344 n336 vdd inv0
x160 n336 n729 vdd inv0
x161 n336 n730 vdd inv0
x162 n337 n731 vdd inv0
x163 n337 n732 vdd inv0
x164 n300 n733 vdd inv0
x165 n733 n734 vdd inv0
x166 n300 n735 vdd inv0
x167 n243 n736 vdd inv0
x168 n243 n737 vdd inv0
x169 n296 n738 vdd inv0
x170 n296 n739 vdd inv0
x171 n241 n740 vdd inv0
x172 n740 n741 vdd inv0
x173 n241 n742 vdd inv0
x174 n742 n743 vdd inv0
x175 n253 n744 vdd inv0
x176 n253 n745 vdd inv0
x177 n233 n746 vdd inv0
x178 n233 n747 vdd inv0
x179 n213 n748 vdd inv0
x180 n213 n749 vdd inv0
x181 n362 n750 vdd inv0
x182 n362 n751 vdd inv0
x183 n356 n752 vdd inv0
x184 n356 n753 vdd inv0
x185 n313 n754 vdd inv0
x186 n313 n755 vdd inv0
x187 n284 n756 vdd inv0
x188 n756 n757 vdd inv0
x189 n284 n758 vdd inv0
x190 n758 n759 vdd inv0
x191 n249 n760 vdd inv0
x192 n249 n761 vdd inv0
x193 n244 n762 vdd inv0
x194 n244 n763 vdd inv0
x195 n223 n764 vdd inv0
x196 n223 n765 vdd inv0
x197 n275 n766 vdd inv0
x198 n275 n767 vdd inv0
x199 n266 n768 vdd inv0
x200 n768 n769 vdd inv0
x201 n266 n770 vdd inv0
x202 n770 n771 vdd inv0
x203 n246 n772 vdd inv0
x204 n772 n773 vdd inv0
x205 n246 n774 vdd inv0
x206 n774 n775 vdd inv0
x207 n364 n776 vdd inv0
x208 n364 n348 vdd inv0
x209 n348 n778 vdd inv0
x210 n348 n779 vdd inv0
x211 n343 n240 vdd inv0
x212 n343 n781 vdd inv0
x213 n197 n782 vdd inv0
x214 n197 n783 vdd inv0
x215 n240 n784 vdd inv0
x216 n240 n785 vdd inv0
x217 n245 n786 vdd inv0
x218 n786 n787 vdd inv0
x219 n245 n788 vdd inv0
x220 n788 n789 vdd inv0
x221 n328 n790 vdd inv0
x222 n328 n791 vdd inv0
x223 n282 n792 vdd inv0
x224 n282 n793 vdd inv0
x225 n235 n794 vdd inv0
x226 n794 n795 vdd inv0
x227 n235 n796 vdd inv0
x228 n796 n797 vdd inv0
x229 n201 n798 vdd inv0
x230 n201 n799 vdd inv0
x231 n325 n800 vdd inv0
x232 n325 n801 vdd inv0
x233 n318 n238 vdd inv0
x234 n318 n803 vdd inv0
x235 n237 n804 vdd inv0
x236 n804 n805 vdd inv0
x237 n237 n806 vdd inv0
x238 n806 n807 vdd inv0
x239 n238 n808 vdd inv0
x240 n238 n809 vdd inv0
x241 n225 n810 vdd inv0
x242 n225 n811 vdd inv0
x243 n222 n812 vdd inv0
x244 n222 n813 vdd inv0
x245 n308 n814 vdd inv0
x246 n308 n815 vdd inv0
x247 n198 n816 vdd inv0
x248 n816 n817 vdd inv0
x249 n198 n818 vdd inv0
x250 n818 n819 vdd inv0
x251 n262 n820 vdd inv0
x252 n262 n821 vdd inv0
x253 n376 n822 vdd inv0
x254 n376 n823 vdd inv0
x255 n374 n360 vdd inv0
x256 n374 n825 vdd inv0
x257 n321 n826 vdd inv0
x258 n321 n317 vdd inv0
x259 n317 n828 vdd inv0
x260 n317 n829 vdd inv0
x261 n287 n830 vdd inv0
x262 n287 n831 vdd inv0
x263 n286 n832 vdd inv0
x264 n286 n330 vdd inv0
x265 n330 n834 vdd inv0
x266 n834 n835 vdd inv0
x267 n330 n836 vdd inv0
x268 n221 n837 vdd inv0
x269 n221 n838 vdd inv0
x270 n195 n839 vdd inv0
x271 n839 n840 vdd inv0
x272 n195 n841 vdd inv0
x273 n841 n842 vdd inv0
x274 n360 n843 vdd inv0
x275 n360 n366 vdd inv0
x276 n366 n845 vdd inv0
x277 n366 n846 vdd inv0
x278 n341 n847 vdd inv0
x279 n341 n848 vdd inv0
x280 n327 n849 vdd inv0
x281 n327 n850 vdd inv0
x282 n270 n851 vdd inv0
x283 n270 n852 vdd inv0
x284 n232 n853 vdd inv0
x285 n853 n854 vdd inv0
x286 n232 n855 vdd inv0
x287 n855 n856 vdd inv0
x288 n205 n857 vdd inv0
x289 n205 n858 vdd inv0
x290 n315 n859 vdd inv0
x291 n315 n276 vdd inv0
x292 n276 n861 vdd inv0
x293 n276 n862 vdd inv0
x294 n211 n863 vdd inv0
x295 n863 n864 vdd inv0
x296 n211 n865 vdd inv0
x297 n865 n866 vdd inv0
x298 n204 n867 vdd inv0
x299 n867 n868 vdd inv0
x300 n204 n869 vdd inv0
x301 n869 n870 vdd inv0
x302 n264 n871 vdd inv0
x303 n264 n872 vdd inv0
x304 n340 n873 vdd inv0
x305 n340 n874 vdd inv0
x306 n338 n875 vdd inv0
x307 n338 n302 vdd inv0
x308 n302 n877 vdd inv0
x309 n302 n878 vdd inv0
x310 n301 n879 vdd inv0
x311 n879 n880 vdd inv0
x312 n301 n881 vdd inv0
x313 n228 n882 vdd inv0
x314 n228 n883 vdd inv0
x315 n194 n884 vdd inv0
x316 n884 n885 vdd inv0
x317 n194 n886 vdd inv0
x318 n886 n887 vdd inv0
x319 n200 n888 vdd inv0
x320 n200 n889 vdd inv0
x321 n331 n277 vdd inv0
x322 n331 n891 vdd inv0
x323 n258 n892 vdd inv0
x324 n258 n893 vdd inv0
x325 n277 n894 vdd inv0
x326 n277 n895 vdd inv0
x327 n273 n896 vdd inv0
x328 n896 n897 vdd inv0
x329 n273 n898 vdd inv0
x330 n214 n899 vdd inv0
x331 n214 n900 vdd inv0
x332 n252 n901 vdd inv0
x333 n901 n902 vdd inv0
x334 n252 n903 vdd inv0
x335 n903 n904 vdd inv0
x336 n230 n905 vdd inv0
x337 n905 n906 vdd inv0
x338 n230 n907 vdd inv0
x339 n907 n908 vdd inv0
x340 n373 n909 vdd inv0
x341 n373 n347 vdd inv0
x342 n347 n911 vdd inv0
x343 n347 n339 vdd inv0
x344 n339 n913 vdd inv0
x345 n339 n914 vdd inv0
x346 n365 n372 vdd inv0
x347 n365 n916 vdd inv0
x348 n247 n917 vdd inv0
x349 n917 n918 vdd inv0
x350 n247 n919 vdd inv0
x351 n919 n920 vdd inv0
x352 n372 n363 vdd inv0
x353 n372 n922 vdd inv0
x354 n220 n923 vdd inv0
x355 n220 n924 vdd inv0
x356 n363 n925 vdd inv0
x357 n363 n926 vdd inv0
x358 n334 n927 vdd inv0
x359 n927 n928 vdd inv0
x360 n334 n265 vdd inv0
x361 n265 n930 vdd inv0
x362 n265 n931 vdd inv0
x363 n354 n932 vdd inv0
x364 n354 n933 vdd inv0
x365 n312 n934 vdd inv0
x366 n312 n935 vdd inv0
x367 n309 n936 vdd inv0
x368 n936 n937 vdd inv0
x369 n309 n938 vdd inv0
x370 n219 n939 vdd inv0
x371 n219 n940 vdd inv0
x372 n349 n281 vdd inv0
x373 n349 n942 vdd inv0
x374 n278 n943 vdd inv0
x375 n943 n944 vdd inv0
x376 n278 n945 vdd inv0
x377 n250 n946 vdd inv0
x378 n250 n947 vdd inv0
x379 n281 n948 vdd inv0
x380 n281 n949 vdd inv0
x381 n283 n950 vdd inv0
x382 n283 n951 vdd inv0
x383 n226 n952 vdd inv0
x384 n952 n953 vdd inv0
x385 n226 n954 vdd inv0
x386 n954 n955 vdd inv0
x387 n350 n956 vdd inv0
x388 n350 n957 vdd inv0
x389 n280 n958 vdd inv0
x390 n958 n959 vdd inv0
x391 n280 n960 vdd inv0
x392 n960 n961 vdd inv0
x393 n190 n962 vdd inv0
x394 n962 n963 vdd inv0
x395 n190 n964 vdd inv0
x396 n964 n965 vdd inv0
x397 n361 n966 vdd inv0
x398 n361 n967 vdd inv0
x399 n333 n968 vdd inv0
x400 n333 n969 vdd inv0
x401 n316 n970 vdd inv0
x402 n970 n971 vdd inv0
x403 n316 n972 vdd inv0
x404 n192 n973 vdd inv0
x405 n192 n974 vdd inv0
x406 n279 n975 vdd inv0
x407 n975 n976 vdd inv0
x408 n279 n977 vdd inv0
x409 n256 n978 vdd inv0
x410 n256 n979 vdd inv0
x411 n311 n980 vdd inv0
x412 n311 n981 vdd inv0
x413 n254 n982 vdd inv0
x414 n254 n983 vdd inv0
x415 n251 n984 vdd inv0
x416 n251 n985 vdd inv0
x417 n202 n986 vdd inv0
x418 n202 n987 vdd inv0
x419 n208 n988 vdd inv0
x420 n988 n989 vdd inv0
x421 n208 n990 vdd inv0
x422 n990 n991 vdd inv0
x423 n319 n992 vdd inv0
x424 n319 n993 vdd inv0
x425 n295 n994 vdd inv0
x426 n295 n995 vdd inv0
x427 n212 n996 vdd inv0
x428 n996 n997 vdd inv0
x429 n212 n998 vdd inv0
x430 n998 n999 vdd inv0
x431 n274 n1000 vdd inv0
x432 n274 n1001 vdd inv0
x433 n358 n1002 vdd inv0
x434 n358 n304 vdd inv0
x435 n304 n1004 vdd inv0
x436 n304 n1005 vdd inv0
x437 n303 n1006 vdd inv0
x438 n303 n1007 vdd inv0
x439 n255 n1008 vdd inv0
x440 n1008 n1009 vdd inv0
x441 n255 n1010 vdd inv0
x442 n1010 n1011 vdd inv0
x443 n210 n1012 vdd inv0
x444 n1012 n1013 vdd inv0
x445 n210 n1014 vdd inv0
x446 n1014 n1015 vdd inv0
x447 n267 n1016 vdd inv0
x448 n267 n1017 vdd inv0
x449 n263 n1018 vdd inv0
x450 n1018 n1019 vdd inv0
x451 n263 n1020 vdd inv0
x452 n1020 n1021 vdd inv0
x453 n346 n1022 vdd inv0
x454 n1022 n1023 vdd inv0
x455 n346 n1024 vdd inv0
x456 n1024 n1025 vdd inv0
x457 n293 n1026 vdd inv0
x458 n1026 n1027 vdd inv0
x459 n293 n1028 vdd inv0
x460 n285 n1029 vdd inv0
x461 n285 n1030 vdd inv0
x462 n196 n1031 vdd inv0
x463 n1031 n1032 vdd inv0
x464 n196 n1033 vdd inv0
x465 n1033 n1034 vdd inv0
x466 n272 n1035 vdd inv0
x467 n272 n1036 vdd inv0
x468 n257 n1037 vdd inv0
x469 n1037 n1038 vdd inv0
x470 n257 n1039 vdd inv0
x471 n1039 n1040 vdd inv0
x472 n224 n1041 vdd inv0
x473 n1041 n1042 vdd inv0
x474 n224 n1043 vdd inv0
x475 n1043 n1044 vdd inv0
*
vdd vdd 0 1.2
vdt gin 0 1.2 pwl(0n 0, 0.2n 0, 0.325n 1.2, 2n 1.2)
*
.ic v(gin)=0
.ic v(n0)=1.2
.ic v(n190)=0
.ic v(n191)=1.2
.ic v(n192)=1.2
.ic v(n193)=0
.ic v(n194)=0
.ic v(n195)=0
.ic v(n196)=0
.ic v(n197)=1.2
.ic v(n198)=0
.ic v(n199)=1.2
.ic v(n200)=1.2
.ic v(n201)=1.2
.ic v(n202)=1.2
.ic v(n203)=1.2
.ic v(n204)=0
.ic v(n205)=1.2
.ic v(n206)=1.2
.ic v(n207)=0
.ic v(n208)=0
.ic v(n209)=0
.ic v(n210)=0
.ic v(n211)=0
.ic v(n212)=0
.ic v(n213)=1.2
.ic v(n214)=1.2
.ic v(n215)=0
.ic v(n216)=1.2
.ic v(n217)=1.2
.ic v(n218)=0
.ic v(n219)=1.2
.ic v(n220)=1.2
.ic v(n221)=1.2
.ic v(n222)=1.2
.ic v(n223)=1.2
.ic v(n224)=0
.ic v(n225)=1.2
.ic v(n226)=0
.ic v(n227)=1.2
.ic v(n228)=1.2
.ic v(n229)=1.2
.ic v(n230)=0
.ic v(n231)=0
.ic v(n232)=0
.ic v(n233)=1.2
.ic v(n234)=0
.ic v(n235)=0
.ic v(n236)=1.2
.ic v(n237)=0
.ic v(n238)=0
.ic v(n239)=1.2
.ic v(n240)=1.2
.ic v(n241)=0
.ic v(n242)=0
.ic v(n243)=1.2
.ic v(n244)=1.2
.ic v(n245)=0
.ic v(n246)=0
.ic v(n247)=0
.ic v(n248)=1.2
.ic v(n249)=0
.ic v(n250)=1.2
.ic v(n251)=1.2
.ic v(n252)=0
.ic v(n253)=0
.ic v(n254)=0
.ic v(n255)=0
.ic v(n256)=1.2
.ic v(n257)=0
.ic v(n258)=1.2
.ic v(n259)=1.2
.ic v(n260)=0
.ic v(n261)=0
.ic v(n262)=1.2
.ic v(n263)=0
.ic v(n264)=1.2
.ic v(n265)=1.2
.ic v(n266)=0
.ic v(n267)=1.2
.ic v(n268)=1.2
.ic v(n269)=0
.ic v(n270)=1.2
.ic v(n271)=1.2
.ic v(n272)=1.2
.ic v(n273)=0
.ic v(n274)=1.2
.ic v(n275)=1.2
.ic v(n276)=1.2
.ic v(n277)=1.2
.ic v(n278)=0
.ic v(n279)=0
.ic v(n280)=0
.ic v(n281)=0
.ic v(n282)=1.2
.ic v(n283)=1.2
.ic v(n284)=0
.ic v(n285)=1.2
.ic v(n286)=1.2
.ic v(n287)=1.2
.ic v(n288)=0
.ic v(n289)=0
.ic v(n290)=1.2
.ic v(n291)=0
.ic v(n292)=1.2
.ic v(n293)=0
.ic v(n294)=0
.ic v(n295)=1.2
.ic v(n296)=1.2
.ic v(n297)=0
.ic v(n298)=1.2
.ic v(n299)=0
.ic v(n300)=0
.ic v(n301)=0
.ic v(n302)=1.2
.ic v(n303)=1.2
.ic v(n304)=0
.ic v(n305)=1.2
.ic v(n306)=0
.ic v(n307)=1.2
.ic v(n308)=1.2
.ic v(n309)=0
.ic v(n310)=0
.ic v(n311)=1.2
.ic v(n312)=1.2
.ic v(n313)=1.2
.ic v(n314)=0
.ic v(n315)=0
.ic v(n316)=0
.ic v(n317)=0
.ic v(n318)=1.2
.ic v(n319)=0
.ic v(n320)=0
.ic v(n321)=1.2
.ic v(n322)=0
.ic v(n323)=1.2
.ic v(n324)=0
.ic v(n325)=0
.ic v(n326)=1.2
.ic v(n327)=0
.ic v(n328)=0
.ic v(n329)=1.2
.ic v(n330)=0
.ic v(n331)=0
.ic v(n332)=1.2
.ic v(n333)=1.2
.ic v(n334)=0
.ic v(n335)=0
.ic v(n336)=0
.ic v(n337)=1.2
.ic v(n338)=0
.ic v(n339)=0
.ic v(n340)=1.2
.ic v(n341)=1.2
.ic v(n342)=1.2
.ic v(n343)=0
.ic v(n344)=1.2
.ic v(n345)=0
.ic v(n346)=0
.ic v(n347)=1.2
.ic v(n348)=1.2
.ic v(n349)=1.2
.ic v(n350)=1.2
.ic v(n351)=1.2
.ic v(n352)=1.2
.ic v(n353)=0
.ic v(n354)=0
.ic v(n355)=0
.ic v(n356)=0
.ic v(n357)=1.2
.ic v(n358)=1.2
.ic v(n359)=0
.ic v(n360)=1.2
.ic v(n361)=0
.ic v(n362)=1.2
.ic v(n363)=1.2
.ic v(n364)=0
.ic v(n365)=1.2
.ic v(n366)=0
.ic v(n367)=1.2
.ic v(n368)=1.2
.ic v(n369)=0
.ic v(n370)=0
.ic v(n371)=1.2
.ic v(n372)=0
.ic v(n373)=0
.ic v(n374)=0
.ic v(n375)=0
.ic v(n376)=1.2
.ic v(n377)=1.2
.ic v(n378)=0
.ic v(n570)=0
.ic v(n571)=1.2
.ic v(n572)=1.2
.ic v(n574)=0
.ic v(n575)=1.2
.ic v(n576)=1.2
.ic v(n577)=0
.ic v(n578)=0
.ic v(n579)=1.2
.ic v(n580)=1.2
.ic v(n581)=0
.ic v(n582)=0
.ic v(n583)=0
.ic v(n584)=0
.ic v(n585)=1.2
.ic v(n586)=0
.ic v(n587)=1.2
.ic v(n588)=0
.ic v(n589)=1.2
.ic v(n590)=0
.ic v(n591)=1.2
.ic v(n592)=0
.ic v(n593)=0
.ic v(n594)=0
.ic v(n596)=1.2
.ic v(n597)=1.2
.ic v(n598)=0
.ic v(n599)=0
.ic v(n600)=0
.ic v(n601)=0
.ic v(n602)=1.2
.ic v(n603)=0
.ic v(n604)=1.2
.ic v(n605)=0
.ic v(n606)=1.2
.ic v(n607)=0
.ic v(n608)=1.2
.ic v(n609)=0
.ic v(n611)=1.2
.ic v(n612)=0
.ic v(n613)=0
.ic v(n615)=0
.ic v(n616)=1.2
.ic v(n617)=1.2
.ic v(n618)=0
.ic v(n619)=0
.ic v(n620)=0
.ic v(n621)=0
.ic v(n622)=1.2
.ic v(n623)=0
.ic v(n625)=0
.ic v(n626)=0
.ic v(n627)=1.2
.ic v(n628)=1.2
.ic v(n629)=0
.ic v(n630)=0
.ic v(n631)=1.2
.ic v(n633)=0
.ic v(n634)=0
.ic v(n635)=1.2
.ic v(n636)=0
.ic v(n638)=0
.ic v(n639)=0
.ic v(n640)=1.2
.ic v(n641)=0
.ic v(n642)=1.2
.ic v(n643)=0
.ic v(n644)=1.2
.ic v(n645)=0
.ic v(n646)=1.2
.ic v(n647)=0
.ic v(n648)=0
.ic v(n649)=0
.ic v(n650)=1.2
.ic v(n652)=0
.ic v(n653)=0
.ic v(n654)=1.2
.ic v(n655)=0
.ic v(n656)=1.2
.ic v(n657)=0
.ic v(n658)=0
.ic v(n659)=1.2
.ic v(n660)=0
.ic v(n661)=1.2
.ic v(n662)=0
.ic v(n663)=1.2
.ic v(n664)=0
.ic v(n665)=1.2
.ic v(n666)=0
.ic v(n667)=0
.ic v(n668)=0
.ic v(n669)=0
.ic v(n670)=1.2
.ic v(n671)=1.2
.ic v(n672)=0
.ic v(n673)=0
.ic v(n674)=0
.ic v(n675)=0
.ic v(n676)=1.2
.ic v(n677)=0
.ic v(n678)=1.2
.ic v(n679)=0
.ic v(n681)=0
.ic v(n682)=1.2
.ic v(n683)=0
.ic v(n684)=1.2
.ic v(n685)=0
.ic v(n687)=1.2
.ic v(n688)=0
.ic v(n689)=0
.ic v(n690)=1.2
.ic v(n691)=0
.ic v(n692)=1.2
.ic v(n693)=0
.ic v(n694)=1.2
.ic v(n695)=0
.ic v(n696)=1.2
.ic v(n697)=0
.ic v(n698)=0
.ic v(n699)=0
.ic v(n700)=0
.ic v(n701)=1.2
.ic v(n702)=0
.ic v(n703)=1.2
.ic v(n704)=0
.ic v(n705)=0
.ic v(n706)=1.2
.ic v(n708)=0
.ic v(n709)=0
.ic v(n710)=1.2
.ic v(n711)=0
.ic v(n712)=1.2
.ic v(n713)=0
.ic v(n714)=1.2
.ic v(n715)=0
.ic v(n716)=1.2
.ic v(n717)=0
.ic v(n718)=0
.ic v(n719)=0
.ic v(n720)=0
.ic v(n721)=1.2
.ic v(n722)=0
.ic v(n723)=1.2
.ic v(n724)=0
.ic v(n726)=1.2
.ic v(n727)=0
.ic v(n729)=1.2
.ic v(n730)=1.2
.ic v(n731)=0
.ic v(n732)=0
.ic v(n733)=1.2
.ic v(n734)=0
.ic v(n735)=1.2
.ic v(n736)=0
.ic v(n737)=0
.ic v(n738)=0
.ic v(n739)=0
.ic v(n740)=1.2
.ic v(n741)=0
.ic v(n742)=1.2
.ic v(n743)=0
.ic v(n744)=1.2
.ic v(n745)=1.2
.ic v(n746)=0
.ic v(n747)=0
.ic v(n748)=0
.ic v(n749)=0
.ic v(n750)=0
.ic v(n751)=0
.ic v(n752)=1.2
.ic v(n753)=1.2
.ic v(n754)=0
.ic v(n755)=0
.ic v(n756)=1.2
.ic v(n757)=0
.ic v(n758)=1.2
.ic v(n759)=0
.ic v(n760)=1.2
.ic v(n761)=1.2
.ic v(n762)=0
.ic v(n763)=0
.ic v(n764)=0
.ic v(n765)=0
.ic v(n766)=0
.ic v(n767)=0
.ic v(n768)=1.2
.ic v(n769)=0
.ic v(n770)=1.2
.ic v(n771)=0
.ic v(n772)=1.2
.ic v(n773)=0
.ic v(n774)=1.2
.ic v(n775)=0
.ic v(n776)=1.2
.ic v(n778)=0
.ic v(n779)=0
.ic v(n781)=1.2
.ic v(n782)=0
.ic v(n783)=0
.ic v(n784)=0
.ic v(n785)=0
.ic v(n786)=1.2
.ic v(n787)=0
.ic v(n788)=1.2
.ic v(n789)=0
.ic v(n790)=1.2
.ic v(n791)=1.2
.ic v(n792)=0
.ic v(n793)=0
.ic v(n794)=1.2
.ic v(n795)=0
.ic v(n796)=1.2
.ic v(n797)=0
.ic v(n798)=0
.ic v(n799)=0
.ic v(n800)=1.2
.ic v(n801)=1.2
.ic v(n803)=0
.ic v(n804)=1.2
.ic v(n805)=0
.ic v(n806)=1.2
.ic v(n807)=0
.ic v(n808)=1.2
.ic v(n809)=1.2
.ic v(n810)=0
.ic v(n811)=0
.ic v(n812)=0
.ic v(n813)=0
.ic v(n814)=0
.ic v(n815)=0
.ic v(n816)=1.2
.ic v(n817)=0
.ic v(n818)=1.2
.ic v(n819)=0
.ic v(n820)=0
.ic v(n821)=0
.ic v(n822)=0
.ic v(n823)=0
.ic v(n825)=1.2
.ic v(n826)=0
.ic v(n828)=1.2
.ic v(n829)=1.2
.ic v(n830)=0
.ic v(n831)=0
.ic v(n832)=0
.ic v(n834)=1.2
.ic v(n835)=0
.ic v(n836)=1.2
.ic v(n837)=0
.ic v(n838)=0
.ic v(n839)=1.2
.ic v(n840)=0
.ic v(n841)=1.2
.ic v(n842)=0
.ic v(n843)=0
.ic v(n845)=1.2
.ic v(n846)=1.2
.ic v(n847)=0
.ic v(n848)=0
.ic v(n849)=1.2
.ic v(n850)=1.2
.ic v(n851)=0
.ic v(n852)=0
.ic v(n853)=1.2
.ic v(n854)=0
.ic v(n855)=1.2
.ic v(n856)=0
.ic v(n857)=0
.ic v(n858)=0
.ic v(n859)=1.2
.ic v(n861)=0
.ic v(n862)=0
.ic v(n863)=1.2
.ic v(n864)=0
.ic v(n865)=1.2
.ic v(n866)=0
.ic v(n867)=1.2
.ic v(n868)=0
.ic v(n869)=1.2
.ic v(n870)=0
.ic v(n871)=0
.ic v(n872)=0
.ic v(n873)=0
.ic v(n874)=0
.ic v(n875)=1.2
.ic v(n877)=0
.ic v(n878)=0
.ic v(n879)=1.2
.ic v(n880)=0
.ic v(n881)=1.2
.ic v(n882)=0
.ic v(n883)=0
.ic v(n884)=1.2
.ic v(n885)=0
.ic v(n886)=1.2
.ic v(n887)=0
.ic v(n888)=0
.ic v(n889)=0
.ic v(n891)=1.2
.ic v(n892)=0
.ic v(n893)=0
.ic v(n894)=0
.ic v(n895)=0
.ic v(n896)=1.2
.ic v(n897)=0
.ic v(n898)=1.2
.ic v(n899)=0
.ic v(n900)=0
.ic v(n901)=1.2
.ic v(n902)=0
.ic v(n903)=1.2
.ic v(n904)=0
.ic v(n905)=1.2
.ic v(n906)=0
.ic v(n907)=1.2
.ic v(n908)=0
.ic v(n909)=1.2
.ic v(n911)=0
.ic v(n913)=1.2
.ic v(n914)=1.2
.ic v(n916)=0
.ic v(n917)=1.2
.ic v(n918)=0
.ic v(n919)=1.2
.ic v(n920)=0
.ic v(n922)=1.2
.ic v(n923)=0
.ic v(n924)=0
.ic v(n925)=0
.ic v(n926)=0
.ic v(n927)=1.2
.ic v(n928)=0
.ic v(n930)=0
.ic v(n931)=0
.ic v(n932)=1.2
.ic v(n933)=1.2
.ic v(n934)=0
.ic v(n935)=0
.ic v(n936)=1.2
.ic v(n937)=0
.ic v(n938)=1.2
.ic v(n939)=0
.ic v(n940)=0
.ic v(n942)=0
.ic v(n943)=1.2
.ic v(n944)=0
.ic v(n945)=1.2
.ic v(n946)=0
.ic v(n947)=0
.ic v(n948)=1.2
.ic v(n949)=1.2
.ic v(n950)=0
.ic v(n951)=0
.ic v(n952)=1.2
.ic v(n953)=0
.ic v(n954)=1.2
.ic v(n955)=0
.ic v(n956)=0
.ic v(n957)=0
.ic v(n958)=1.2
.ic v(n959)=0
.ic v(n960)=1.2
.ic v(n961)=0
.ic v(n962)=1.2
.ic v(n963)=0
.ic v(n964)=1.2
.ic v(n965)=0
.ic v(n966)=1.2
.ic v(n967)=1.2
.ic v(n968)=0
.ic v(n969)=0
.ic v(n970)=1.2
.ic v(n971)=0
.ic v(n972)=1.2
.ic v(n973)=0
.ic v(n974)=0
.ic v(n975)=1.2
.ic v(n976)=0
.ic v(n977)=1.2
.ic v(n978)=0
.ic v(n979)=0
.ic v(n980)=0
.ic v(n981)=0
.ic v(n982)=1.2
.ic v(n983)=1.2
.ic v(n984)=0
.ic v(n985)=0
.ic v(n986)=0
.ic v(n987)=0
.ic v(n988)=1.2
.ic v(n989)=0
.ic v(n990)=1.2
.ic v(n991)=0
.ic v(n992)=1.2
.ic v(n993)=1.2
.ic v(n994)=0
.ic v(n995)=0
.ic v(n996)=1.2
.ic v(n997)=0
.ic v(n998)=1.2
.ic v(n999)=0
.ic v(n1000)=0
.ic v(n1001)=0
.ic v(n1002)=0
.ic v(n1004)=1.2
.ic v(n1005)=1.2
.ic v(n1006)=0
.ic v(n1007)=0
.ic v(n1008)=1.2
.ic v(n1009)=0
.ic v(n1010)=1.2
.ic v(n1011)=0
.ic v(n1012)=1.2
.ic v(n1013)=0
.ic v(n1014)=1.2
.ic v(n1015)=0
.ic v(n1016)=0
.ic v(n1017)=0
.ic v(n1018)=1.2
.ic v(n1019)=0
.ic v(n1020)=1.2
.ic v(n1021)=0
.ic v(n1022)=1.2
.ic v(n1023)=0
.ic v(n1024)=1.2
.ic v(n1025)=0
.ic v(n1026)=1.2
.ic v(n1027)=0
.ic v(n1028)=1.2
.ic v(n1029)=0
.ic v(n1030)=0
.ic v(n1031)=1.2
.ic v(n1032)=0
.ic v(n1033)=1.2
.ic v(n1034)=0
.ic v(n1035)=0
.ic v(n1036)=0
.ic v(n1037)=1.2
.ic v(n1038)=0
.ic v(n1039)=1.2
.ic v(n1040)=0
.ic v(n1041)=1.2
.ic v(n1042)=0
.ic v(n1043)=1.2
.ic v(n1044)=0
.ic v(n380)=0
.ic v(n381)=0
.ic v(n382)=0
.ic v(n383)=0
.ic v(n384)=0
.ic v(n385)=0
.ic v(n386)=0
.ic v(n387)=0
.ic v(n388)=0
.ic v(n389)=0
.ic v(n390)=0
.ic v(n391)=0
.ic v(n392)=0
.ic v(n393)=0
.ic v(n394)=0
.ic v(n395)=0
.ic v(n396)=0
.ic v(n397)=0
.ic v(n398)=0
.ic v(n399)=0
.ic v(n400)=0
.ic v(n401)=0
.ic v(n402)=0
.ic v(n403)=0
.ic v(n404)=0
.ic v(n405)=0
.ic v(n406)=0
.ic v(n407)=0
.ic v(n408)=0
.ic v(n409)=0
.ic v(n410)=0
.ic v(n411)=0
.ic v(n412)=0
.ic v(n413)=0
.ic v(n414)=0
.ic v(n415)=0
.ic v(n416)=0
.ic v(n417)=0
.ic v(n418)=0
.ic v(n419)=0
.ic v(n420)=0
.ic v(n421)=0
.ic v(n422)=0
.ic v(n423)=0
.ic v(n424)=0
.ic v(n425)=0
.ic v(n426)=0
.ic v(n427)=0
.ic v(n428)=0
.ic v(n429)=0
.ic v(n430)=0
.ic v(n431)=0
.ic v(n432)=0
.ic v(n433)=0
.ic v(n434)=0
.ic v(n435)=0
.ic v(n436)=0
.ic v(n437)=0
.ic v(n438)=0
.ic v(n439)=0
.ic v(n440)=0
.ic v(n441)=0
.ic v(n442)=0
.ic v(n443)=0
.ic v(n444)=0
.ic v(n445)=0
.ic v(n446)=0
.ic v(n447)=0
.ic v(n448)=0
.ic v(n449)=0
.ic v(n450)=0
.ic v(n451)=0
.ic v(n452)=0
.ic v(n453)=0
.ic v(n454)=0
.ic v(n455)=0
.ic v(n456)=0
.ic v(n457)=0
.ic v(n458)=0
.ic v(n459)=0
.ic v(n460)=0
.ic v(n461)=0
.ic v(n462)=0
.ic v(n463)=0
.ic v(n464)=0
.ic v(n465)=0
.ic v(n466)=0
.ic v(n467)=0
.ic v(n468)=0
.ic v(n469)=0
.ic v(n470)=0
.ic v(n471)=0
.ic v(n472)=0
.ic v(n473)=0
.ic v(n474)=0
.ic v(n475)=0
.ic v(n476)=0
.ic v(n477)=0
.ic v(n478)=0
.ic v(n479)=0
.ic v(n480)=0
.ic v(n481)=0
.ic v(n482)=0
.ic v(n483)=0
.ic v(n484)=0
.ic v(n485)=0
.ic v(n486)=0
.ic v(n487)=0
.ic v(n488)=0
.ic v(n489)=0
.ic v(n490)=0
.ic v(n491)=0
.ic v(n492)=0
.ic v(n493)=0
.ic v(n494)=0
.ic v(n495)=0
.ic v(n496)=0
.ic v(n497)=0
.ic v(n498)=0
.ic v(n499)=0
.ic v(n500)=0
.ic v(n501)=0
.ic v(n502)=0
.ic v(n503)=0
.ic v(n504)=0
.ic v(n505)=0
.ic v(n506)=0
.ic v(n507)=0
.ic v(n508)=0
.ic v(n509)=0
.ic v(n510)=0
.ic v(n511)=0
.ic v(n512)=0
.ic v(n513)=0
.ic v(n514)=0
.ic v(n515)=0
.ic v(n516)=0
.ic v(n517)=0
.ic v(n518)=0
.ic v(n519)=0
.ic v(n520)=0
.ic v(n521)=0
.ic v(n522)=0
.ic v(n523)=0
.ic v(n524)=0
.ic v(n525)=0
.ic v(n526)=0
.ic v(n527)=0
.ic v(n528)=0
.ic v(n529)=0
.ic v(n530)=0
.ic v(n531)=0
.ic v(n532)=0
.ic v(n533)=0
.ic v(n534)=0
.ic v(n535)=0
.ic v(n536)=0
.ic v(n537)=0
.ic v(n538)=0
.ic v(n539)=0
.ic v(n540)=0
.ic v(n541)=0
.ic v(n542)=0
.ic v(n543)=0
.ic v(n544)=0
.ic v(n545)=0
.ic v(n546)=0
.ic v(n547)=0
.ic v(n548)=0
.ic v(n549)=0
.ic v(n550)=0
.ic v(n551)=0
.ic v(n552)=0
.ic v(n553)=0
.ic v(n554)=0
.ic v(n555)=0
.ic v(n556)=0
.ic v(n557)=0
.ic v(n558)=0
.ic v(n559)=0
.ic v(n560)=0
.ic v(n561)=0
.ic v(n562)=0
.ic v(n563)=0
.ic v(n564)=0
.ic v(n565)=0
.ic v(n566)=0
.ic v(n567)=0
.ic v(n568)=0
.ic v(n569)=0
.ic v(nSEG_NODE_855)=1.2
.ic v(nSEG_NODE_856)=1.2
.ic v(nSEG_NODE_857)=1.2
.ic v(nSEG_NODE_858)=1.2
.ic v(nSEG_NODE_859)=1.2
.ic v(nSEG_NODE_860)=1.2
.ic v(nSEG_NODE_861)=1.2
.ic v(nSEG_NODE_862)=1.2
.ic v(nSEG_NODE_863)=1.2
.ic v(nSEG_NODE_864)=1.2
.ic v(nSEG_NODE_865)=1.2
.ic v(nSEG_NODE_866)=1.2
.ic v(nSEG_NODE_867)=1.2
.ic v(nSEG_NODE_868)=1.2
.ic v(nSEG_NODE_869)=1.2
.ic v(nSEG_NODE_870)=1.2
.ic v(nSEG_NODE_871)=1.2
.ic v(nSEG_NODE_872)=1.2
.ic v(nSEG_NODE_873)=1.2
.ic v(nSEG_NODE_874)=1.2
.ic v(nSEG_NODE_875)=1.2
.ic v(nSEG_NODE_876)=1.2
.ic v(nSEG_NODE_877)=1.2
.ic v(nSEG_NODE_878)=1.2
.ic v(nSEG_NODE_879)=1.2
.ic v(nSEG_NODE_880)=1.2
.ic v(nSEG_NODE_881)=1.2
.ic v(nSEG_NODE_882)=1.2
.ic v(nSEG_NODE_883)=1.2
.ic v(nSEG_NODE_884)=1.2
.ic v(nSEG_NODE_885)=1.2
.ic v(nSEG_NODE_886)=1.2
.ic v(nSEG_NODE_887)=1.2
.ic v(nSEG_NODE_888)=1.2
.ic v(nSEG_NODE_889)=1.2
.ic v(nSEG_NODE_890)=1.2
.ic v(nSEG_NODE_891)=1.2
.ic v(nSEG_NODE_892)=1.2
.ic v(nSEG_NODE_893)=1.2
.ic v(nSEG_NODE_894)=1.2
.ic v(nSEG_NODE_895)=1.2
.ic v(nSEG_NODE_896)=1.2
.ic v(nSEG_NODE_897)=1.2
.ic v(nSEG_NODE_898)=1.2
.ic v(nSEG_NODE_899)=1.2
.ic v(nSEG_NODE_900)=1.2
.ic v(nSEG_NODE_901)=1.2
.ic v(nSEG_NODE_902)=1.2
.ic v(nSEG_NODE_903)=1.2
.ic v(nSEG_NODE_904)=1.2
.ic v(nSEG_NODE_905)=1.2
.ic v(nSEG_NODE_906)=1.2
.ic v(nSEG_NODE_907)=1.2
.ic v(nSEG_NODE_908)=1.2
.ic v(nSEG_NODE_909)=1.2
.ic v(nSEG_NODE_910)=1.2
.ic v(nSEG_NODE_911)=1.2
.ic v(nSEG_NODE_912)=1.2
.ic v(nSEG_NODE_913)=1.2
.ic v(nSEG_NODE_914)=1.2
.ic v(nSEG_NODE_915)=1.2
.ic v(nSEG_NODE_916)=1.2
.ic v(nSEG_NODE_917)=1.2
.ic v(nSEG_NODE_918)=1.2
.ic v(nSEG_NODE_919)=1.2
.ic v(nSEG_NODE_920)=1.2
.ic v(nSEG_NODE_921)=1.2
.ic v(nSEG_NODE_922)=1.2
.ic v(nSEG_NODE_923)=1.2
.ic v(nSEG_NODE_924)=1.2
.ic v(nSEG_NODE_925)=1.2
.ic v(nSEG_NODE_926)=1.2
.ic v(nSEG_NODE_927)=1.2
.ic v(nSEG_NODE_928)=1.2
.ic v(nSEG_NODE_929)=1.2
.ic v(nSEG_NODE_930)=1.2
.ic v(nSEG_NODE_931)=1.2
.ic v(nSEG_NODE_932)=1.2
.ic v(nSEG_NODE_933)=1.2
.ic v(nSEG_NODE_934)=1.2
.ic v(nSEG_NODE_935)=1.2
.ic v(nSEG_NODE_936)=1.2
.ic v(nSEG_NODE_937)=1.2
.ic v(nSEG_NODE_938)=1.2
.ic v(nSEG_NODE_939)=1.2
.ic v(nSEG_NODE_940)=1.2
.ic v(nSEG_NODE_941)=1.2
.ic v(nSEG_NODE_942)=1.2
.ic v(nSEG_NODE_943)=1.2
.ic v(nSEG_NODE_944)=1.2
.ic v(nSEG_NODE_945)=1.2
.ic v(nSEG_NODE_946)=1.2
.ic v(nSEG_NODE_947)=1.2
.ic v(nSEG_NODE_948)=1.2
.ic v(nSEG_NODE_949)=1.2
.ic v(nSEG_NODE_950)=1.2
.ic v(nSEG_NODE_951)=1.2
.ic v(nSEG_NODE_952)=1.2
.ic v(nSEG_NODE_953)=1.2
.ic v(nSEG_NODE_954)=1.2
.ic v(nSEG_NODE_955)=1.2
.ic v(nSEG_NODE_956)=1.2
.ic v(nSEG_NODE_957)=1.2
.ic v(nSEG_NODE_958)=1.2
.ic v(nSEG_NODE_959)=1.2
.ic v(nSEG_NODE_960)=1.2
.ic v(nSEG_NODE_961)=1.2
.ic v(nSEG_NODE_962)=1.2
.ic v(nSEG_NODE_963)=1.2
.ic v(nSEG_NODE_964)=1.2
.ic v(nSEG_NODE_965)=1.2
.ic v(nSEG_NODE_966)=1.2
.ic v(nSEG_NODE_967)=1.2
.ic v(nSEG_NODE_968)=1.2
.ic v(nSEG_NODE_969)=1.2
.ic v(nSEG_NODE_970)=1.2
.ic v(nSEG_NODE_971)=1.2
.ic v(nSEG_NODE_972)=1.2
.ic v(nSEG_NODE_973)=1.2
.ic v(nSEG_NODE_974)=1.2
.ic v(nSEG_NODE_975)=1.2
.ic v(nSEG_NODE_976)=1.2
.ic v(nSEG_NODE_977)=1.2
.ic v(nSEG_NODE_978)=1.2
.ic v(nSEG_NODE_979)=1.2
.ic v(nSEG_NODE_980)=1.2
.ic v(nSEG_NODE_981)=1.2
.ic v(nSEG_NODE_982)=1.2
.ic v(nSEG_NODE_983)=1.2
.ic v(nSEG_NODE_984)=1.2
.ic v(nSEG_NODE_985)=1.2
.ic v(nSEG_NODE_986)=1.2
.ic v(nSEG_NODE_987)=1.2
.ic v(nSEG_NODE_988)=1.2
.ic v(nSEG_NODE_989)=1.2
.ic v(nSEG_NODE_990)=1.2
.ic v(nSEG_NODE_991)=1.2
.ic v(nSEG_NODE_992)=1.2
.ic v(nSEG_NODE_993)=1.2
.ic v(nSEG_NODE_994)=1.2
.ic v(nSEG_NODE_995)=1.2
.ic v(nSEG_NODE_996)=1.2
.ic v(nSEG_NODE_997)=1.2
.ic v(nSEG_NODE_998)=1.2
.ic v(nSEG_NODE_999)=1.2
.ic v(nSEG_NODE_1000)=1.2
.ic v(nSEG_NODE_1001)=1.2
.ic v(nSEG_NODE_1002)=1.2
.ic v(nSEG_NODE_1003)=1.2
.ic v(nSEG_NODE_1004)=1.2
.ic v(nSEG_NODE_1005)=1.2
.ic v(nSEG_NODE_1006)=1.2
.ic v(nSEG_NODE_1007)=1.2
.ic v(nSEG_NODE_1008)=1.2
.ic v(nSEG_NODE_1009)=1.2
.ic v(nSEG_NODE_1010)=1.2
.ic v(nSEG_NODE_1011)=1.2
.ic v(nSEG_NODE_1012)=1.2
.ic v(nSEG_NODE_1013)=1.2
.ic v(nSEG_NODE_1014)=1.2
.ic v(nSEG_NODE_1015)=1.2
.ic v(nSEG_NODE_1016)=1.2
.ic v(nSEG_NODE_1017)=1.2
.ic v(nSEG_NODE_1018)=1.2
.ic v(nSEG_NODE_1019)=1.2
.ic v(nSEG_NODE_1020)=1.2
.ic v(nSEG_NODE_1021)=1.2
.ic v(nSEG_NODE_1022)=1.2
.ic v(nSEG_NODE_1023)=1.2
.ic v(nSEG_NODE_1024)=1.2
.ic v(nSEG_NODE_1025)=1.2
.ic v(nSEG_NODE_1026)=1.2
.ic v(nSEG_NODE_1027)=1.2
.ic v(nSEG_NODE_1028)=1.2
.ic v(nSEG_NODE_1029)=1.2
.ic v(nSEG_NODE_1030)=1.2
.ic v(nSEG_NODE_1031)=1.2
.ic v(nSEG_NODE_1032)=1.2
.ic v(nSEG_NODE_1033)=1.2
.ic v(nSEG_NODE_1034)=1.2
.ic v(nSEG_NODE_1035)=1.2
.ic v(nSEG_NODE_1036)=1.2
.ic v(nSEG_NODE_1037)=1.2
.ic v(nSEG_NODE_1038)=1.2
.ic v(nSEG_NODE_1039)=1.2
.ic v(nSEG_NODE_1040)=1.2
.ic v(nSEG_NODE_1041)=1.2
.ic v(nSEG_NODE_1042)=1.2
.ic v(nSEG_NODE_1043)=1.2
.ic v(nSEG_NODE_1044)=1.2
.ic v(nSEG_NODE_1045)=1.2
.ic v(nSEG_NODE_1046)=1.2
.ic v(nSEG_NODE_1047)=1.2
.ic v(nSEG_NODE_1048)=1.2
.ic v(nSEG_NODE_1049)=1.2
.ic v(nSEG_NODE_1050)=1.2
.ic v(nSEG_NODE_1051)=1.2
.ic v(nSEG_NODE_1052)=1.2
.ic v(nSEG_NODE_1053)=1.2
.ic v(nSEG_NODE_1054)=1.2
.ic v(nSEG_NODE_1055)=1.2
.ic v(nSEG_NODE_1056)=1.2
.ic v(nSEG_NODE_1057)=1.2
.ic v(nSEG_NODE_1058)=1.2
.ic v(nSEG_NODE_1059)=1.2
.ic v(nSEG_NODE_1060)=1.2
.ic v(nSEG_NODE_1061)=1.2
.ic v(nSEG_NODE_1062)=1.2
.ic v(nSEG_NODE_1063)=1.2
.ic v(nSEG_NODE_1064)=1.2
.ic v(nSEG_NODE_1065)=1.2
.ic v(nSEG_NODE_1066)=1.2
.ic v(nSEG_NODE_1067)=1.2
.ic v(nSEG_NODE_1068)=1.2
.ic v(nSEG_NODE_1069)=1.2
.ic v(nSEG_NODE_1070)=1.2
.ic v(nSEG_NODE_1071)=1.2
.ic v(nSEG_NODE_1072)=1.2
.ic v(nSEG_NODE_1073)=1.2
.ic v(nSEG_NODE_1074)=1.2
.ic v(nSEG_NODE_1075)=1.2
.ic v(nSEG_NODE_1076)=1.2
.ic v(nSEG_NODE_1077)=1.2
.ic v(nSEG_NODE_1078)=1.2
.ic v(nSEG_NODE_1079)=1.2
.ic v(nSEG_NODE_1080)=1.2
.ic v(nSEG_NODE_1081)=1.2
.ic v(nSEG_NODE_1082)=1.2
.ic v(nSEG_NODE_1083)=1.2
.ic v(nSEG_NODE_1084)=1.2
.ic v(nSEG_NODE_1085)=1.2
.ic v(nSEG_NODE_1086)=1.2
.ic v(nSEG_NODE_1087)=1.2
.ic v(nSEG_NODE_1088)=1.2
.ic v(nSEG_NODE_1089)=1.2
.ic v(nSEG_NODE_1090)=1.2
.ic v(nSEG_NODE_1091)=1.2
.ic v(nSEG_NODE_1092)=1.2
.ic v(nSEG_NODE_1093)=1.2
.ic v(nSEG_NODE_1094)=1.2
.ic v(nSEG_NODE_1095)=1.2
.ic v(nSEG_NODE_1096)=1.2
.ic v(nSEG_NODE_1097)=1.2
.ic v(nSEG_NODE_1098)=1.2
.ic v(nSEG_NODE_1099)=1.2
.ic v(nSEG_NODE_1100)=1.2
.ic v(nSEG_NODE_1101)=1.2
.ic v(nSEG_NODE_1102)=1.2
.ic v(nSEG_NODE_1103)=1.2
.ic v(nSEG_NODE_1104)=1.2
.ic v(nSEG_NODE_1105)=1.2
.ic v(nSEG_NODE_1106)=1.2
.ic v(nSEG_NODE_1107)=1.2
.ic v(nSEG_NODE_1108)=1.2
.ic v(nSEG_NODE_1109)=1.2
.ic v(nSEG_NODE_1110)=1.2
.ic v(nSEG_NODE_1111)=1.2
.ic v(nSEG_NODE_1112)=1.2
.ic v(nSEG_NODE_1113)=1.2
.ic v(nSEG_NODE_1114)=1.2
.ic v(nSEG_NODE_1115)=1.2
.ic v(nSEG_NODE_1116)=1.2
.ic v(nSEG_NODE_1117)=1.2
.ic v(nSEG_NODE_1118)=1.2
.ic v(nSEG_NODE_1119)=1.2
.ic v(nSEG_NODE_1120)=1.2
.ic v(nSEG_NODE_1121)=1.2
.ic v(nSEG_NODE_1122)=1.2
.ic v(nSEG_NODE_1123)=1.2
.ic v(nSEG_NODE_1124)=1.2
.ic v(nSEG_NODE_1125)=1.2
.ic v(nSEG_NODE_1126)=1.2
.ic v(nSEG_NODE_1127)=1.2
.ic v(nSEG_NODE_1128)=1.2
.ic v(nSEG_NODE_1129)=1.2
.ic v(nSEG_NODE_1130)=1.2
.ic v(nSEG_NODE_1131)=1.2
.ic v(nSEG_NODE_1132)=1.2
.ic v(nSEG_NODE_1133)=1.2
.ic v(nSEG_NODE_1134)=1.2
.ic v(nSEG_NODE_1135)=1.2
.ic v(nSEG_NODE_1136)=1.2
.ic v(nSEG_NODE_1137)=1.2
.ic v(nSEG_NODE_1138)=1.2
.ic v(nSEG_NODE_1139)=1.2
.ic v(nSEG_NODE_1140)=1.2
.ic v(nSEG_NODE_1141)=1.2
.ic v(nSEG_NODE_1142)=1.2
.ic v(nSEG_NODE_1143)=1.2
.ic v(nSEG_NODE_1144)=1.2
.ic v(nSEG_NODE_1145)=1.2
.ic v(nSEG_NODE_1146)=1.2
.ic v(nSEG_NODE_1147)=1.2
.ic v(nSEG_NODE_1148)=1.2
.ic v(nSEG_NODE_1149)=1.2
.ic v(nSEG_NODE_1150)=1.2
.ic v(nSEG_NODE_1151)=1.2
.ic v(nSEG_NODE_1152)=1.2
.ic v(nSEG_NODE_1153)=1.2
.ic v(nSEG_NODE_1154)=1.2
.ic v(nSEG_NODE_1155)=1.2
.ic v(nSEG_NODE_1156)=1.2
.ic v(nSEG_NODE_1157)=1.2
.ic v(nSEG_NODE_1158)=1.2
.ic v(nSEG_NODE_1159)=1.2
.ic v(nSEG_NODE_1160)=1.2
.ic v(nSEG_NODE_1161)=1.2
.ic v(nSEG_NODE_1162)=1.2
.ic v(nSEG_NODE_1163)=1.2
.ic v(nSEG_NODE_1164)=1.2
.ic v(nSEG_NODE_1165)=1.2
.ic v(nSEG_NODE_1166)=1.2
.ic v(nSEG_NODE_1167)=1.2
.ic v(nSEG_NODE_1168)=1.2
.ic v(nSEG_NODE_1169)=1.2
.ic v(nSEG_NODE_1170)=1.2
.ic v(nSEG_NODE_1171)=1.2
.ic v(nSEG_NODE_1172)=1.2
.ic v(nSEG_NODE_1173)=1.2
.ic v(nSEG_NODE_1174)=1.2
.ic v(nSEG_NODE_1175)=1.2
.ic v(nSEG_NODE_1176)=1.2
.ic v(nSEG_NODE_1177)=1.2
.ic v(nSEG_NODE_1178)=1.2
.ic v(nSEG_NODE_1179)=1.2
.ic v(nSEG_NODE_1180)=1.2
.ic v(nSEG_NODE_1181)=1.2
.ic v(nSEG_NODE_1182)=1.2
.ic v(nSEG_NODE_1183)=1.2
.ic v(nSEG_NODE_1184)=1.2
.ic v(nSEG_NODE_1185)=1.2
.ic v(nSEG_NODE_1186)=1.2
.ic v(nSEG_NODE_1187)=1.2
.ic v(nSEG_NODE_1188)=1.2
.ic v(nSEG_NODE_1189)=1.2
.ic v(nSEG_NODE_1190)=1.2
.ic v(nSEG_NODE_1191)=1.2
.ic v(nSEG_NODE_1192)=1.2
.ic v(nSEG_NODE_1193)=1.2
.ic v(nSEG_NODE_1194)=1.2
.ic v(nSEG_NODE_1195)=1.2
.ic v(nSEG_NODE_1196)=1.2
.ic v(nSEG_NODE_1197)=1.2
.ic v(nSEG_NODE_1198)=1.2
.ic v(nSEG_NODE_1199)=1.2
.ic v(nSEG_NODE_1200)=1.2
.ic v(nSEG_NODE_1201)=1.2
.ic v(nSEG_NODE_1202)=1.2
.ic v(nSEG_NODE_1203)=1.2
.ic v(nSEG_NODE_1204)=1.2
.ic v(nSEG_NODE_1205)=1.2
.ic v(nSEG_NODE_1206)=1.2
.ic v(nSEG_NODE_1207)=1.2
.ic v(nSEG_NODE_1208)=1.2
.ic v(nSEG_NODE_1209)=1.2
.ic v(nSEG_NODE_1210)=1.2
.ic v(nSEG_NODE_1211)=1.2
.ic v(nSEG_NODE_1212)=1.2
.ic v(nSEG_NODE_1213)=1.2
.ic v(nSEG_NODE_1214)=1.2
.ic v(nSEG_NODE_1215)=1.2
.ic v(nSEG_NODE_1216)=1.2
.ic v(nSEG_NODE_1217)=1.2
.ic v(nSEG_NODE_1218)=1.2
.ic v(nSEG_NODE_1219)=1.2
.ic v(nSEG_NODE_1220)=1.2
.ic v(nSEG_NODE_1221)=1.2
.ic v(nSEG_NODE_1222)=1.2
.ic v(nSEG_NODE_1223)=1.2
.ic v(nSEG_NODE_1224)=1.2
.ic v(nSEG_NODE_1225)=1.2
.ic v(nSEG_NODE_1226)=1.2
.ic v(nSEG_NODE_1227)=1.2
.ic v(nSEG_NODE_1228)=1.2
.ic v(nSEG_NODE_1229)=1.2
.ic v(nSEG_NODE_1230)=1.2
.ic v(nSEG_NODE_1231)=1.2
.ic v(nSEG_NODE_1232)=1.2
.ic v(nSEG_NODE_1233)=1.2
.ic v(nSEG_NODE_1234)=1.2
.ic v(nSEG_NODE_1235)=1.2
.ic v(nSEG_NODE_1236)=1.2
.ic v(nSEG_NODE_1237)=1.2
.ic v(nSEG_NODE_1238)=1.2
.ic v(nSEG_NODE_1239)=1.2
.ic v(nSEG_NODE_1240)=1.2
.ic v(nSEG_NODE_1241)=1.2
.ic v(nSEG_NODE_1242)=1.2
.ic v(nSEG_NODE_1243)=1.2
*
.opti nopage temp=75
.width out=240
*
.tran 0.01n 2n 0.0n 0.01n
* .print tran v(gin) v(n0) v(n378) v(n377) v(n353) v(n342) v(n322) v(n298) v(n292) v(n289) v(n585) v(n587) v(n269) v(n589) v(n227) v(n332) v(n324) v(n217) v(n305) v(n234) v(n602) v(n604) v(n207) v(n606) v(n608) v(n369) v(n236) v(n352) v(n297) v(n248) v(n239) v(n291) v(n622) v(n368) v(n375) v(n371) v(n359) v(n323) v(n320) v(n635) v(n290) v(n242) v(n640) v(n642) v(n215) v(n644) v(n646) v(n191) v(n355) v(n351) v(n345) v(n654) v(n268) v(n231) v(n659) v(n661) v(n299) v(n663) v(n229) v(n326) v(n261) v(n206) v(n203) v(n260) v(n676) v(n678) v(n367) v(n209) v(n682) v(n684) v(n335) v(n329) v(n218) v(n690) v(n692) v(n294) v(n694) v(n216) v(n357) v(n310) v(n701) v(n259) v(n314) v(n307) v(n306) v(n710) v(n712) v(n288) v(n714) v(n199) v(n271) v(n193) v(n721) v(n723) v(n370) v(n344) v(n336) v(n337) v(n300) v(n733) v(n243) v(n296) v(n241) v(n740) v(n742) v(n253) v(n233) v(n213) v(n362) v(n356) v(n313) v(n284) v(n756) v(n758) v(n249) v(n244) v(n223) v(n275) v(n266) v(n768) v(n770) v(n246) v(n772) v(n774) v(n364) v(n348) v(n343) v(n197) v(n240) v(n245) v(n786) v(n788) v(n328) v(n282) v(n235) v(n794) v(n796) v(n201) v(n325) v(n318) v(n237) v(n804) v(n806) v(n238) v(n225) v(n222) v(n308) v(n198) v(n816) v(n818) v(n262) v(n376) v(n374) v(n321) v(n317) v(n287) v(n286) v(n330) v(n834) v(n221) v(n195) v(n839) v(n841) v(n360) v(n366) v(n341) v(n327) v(n270) v(n232) v(n853) v(n855) v(n205) v(n315) v(n276) v(n211) v(n863) v(n865) v(n204) v(n867) v(n869) v(n264) v(n340) v(n338) v(n302) v(n301) v(n879) v(n228) v(n194) v(n884) v(n886) v(n200) v(n331) v(n258) v(n277) v(n273) v(n896) v(n214) v(n252) v(n901) v(n903) v(n230) v(n905) v(n907) v(n373) v(n347) v(n339) v(n365) v(n247) v(n917) v(n919) v(n372) v(n220) v(n363) v(n334) v(n927) v(n265) v(n354) v(n312) v(n309) v(n936) v(n219) v(n349) v(n278) v(n943) v(n250) v(n281) v(n283) v(n226) v(n952) v(n954) v(n350) v(n280) v(n958) v(n960) v(n190) v(n962) v(n964) v(n361) v(n333) v(n316) v(n970) v(n192) v(n279) v(n975) v(n256) v(n311) v(n254) v(n251) v(n202) v(n208) v(n988) v(n990) v(n319) v(n295) v(n212) v(n996) v(n998) v(n274) v(n358) v(n304) v(n303) v(n255) v(n1008) v(n1010) v(n210) v(n1012) v(n1014) v(n267) v(n263) v(n1018) v(n1020) v(n346) v(n1022) v(n1024) v(n293) v(n1026) v(n285) v(n196) v(n1031) v(n1033) v(n272) v(n257) v(n1037) v(n1039) v(n224) v(n1041) v(n1043) v(n380) v(n381) v(n382) v(n383) v(n384) v(n385) v(n386) v(n387) v(n388) v(n389) v(n390) v(n391) v(n392) v(n393) v(n394) v(n715) v(n396) v(n397) v(n398) v(n399) v(n400) v(n737) v(n402) v(n403) v(n404) v(n405) v(n406) v(n407) v(n408) v(n409) v(n410) v(n411) v(n412) v(n413) v(n414) v(n415) v(n416) v(n417) v(n418) v(n419) v(n420) v(n421) v(n687) v(n423) v(n424) v(n425) v(n426) v(n427) v(n428) v(n429) v(n430) v(n431) v(n432) v(n433) v(n434) v(n435) v(n436) v(n437) v(n438) v(n439) v(n742) v(n441) v(n442) v(n716) v(n444) v(n445) v(n446) v(n447) v(n448) v(n449) v(n450) v(n451) v(n452) v(n453) v(n454) v(n455) v(n456) v(n457) v(n458) v(n459) v(n460) v(n461) v(n462) v(n463) v(n464) v(n465) v(n466) v(n467) v(n468) v(n469) v(n470) v(n471) v(n472) v(n473) v(n474) v(n475) v(n476) v(n477) v(n478) v(n479) v(n480) v(n481) v(n482) v(n483) v(n484) v(n485) v(n486) v(n487) v(n488) v(n489) v(n490) v(n491) v(n728) v(n493) v(n494) v(n620) v(n496) v(n497) v(n498) v(n499) v(n500) v(n501) v(n502) v(n503) v(n504) v(n505) v(n506) v(n507) v(n508) v(n509) v(n510) v(n511) v(n512) v(n513) v(n514) v(n515) v(n516) v(n618) v(n518) v(n519) v(n520) v(n521) v(n522) v(n523) v(n524) v(n525) v(n526) v(n527) v(n528) v(n529) v(n530) v(n531) v(n532) v(n533) v(n534) v(n535) v(n536) v(n537) v(n538) v(n740) v(n540) v(n541) v(n697) v(n543) v(n544) v(n545) v(n546) v(n547) v(n710) v(n549) v(n550) v(n551) v(n552) v(n553) v(n554) v(n555) v(n556) v(n557) v(n558) v(n746) v(n560) v(n561) v(n562) v(n563) v(n564) v(n565) v(n566) v(n567) v(n568) v(n569)
.print tran all
* plot v(gin) v(n0) v(n378) v(n377) v(n353) v(n342) v(n322) v(n298) v(n292) v(n289) v(n585) v(n587) v(n269) v(n589) v(n227) v(n332) v(n324) v(n217) v(n305) v(n234) v(n602) v(n604) v(n207) v(n606) v(n608) v(n369) v(n236) v(n352) v(n297) v(n248) v(n239) v(n291) v(n622) v(n368) v(n375) v(n371) v(n359) v(n323) v(n320) v(n635) v(n290) v(n242) v(n640) v(n642) v(n215) v(n644) v(n646) v(n191) v(n355) v(n351) v(n345) v(n654) v(n268) v(n231) v(n659) v(n661) v(n299) v(n663) v(n229) v(n326) v(n261) v(n206) v(n203) v(n260) v(n676) v(n678) v(n367) v(n209) v(n682) v(n684) v(n335) v(n329) v(n218) v(n690) v(n692) v(n294) v(n694) v(n216) v(n357) v(n310) v(n701) v(n259) v(n314) v(n307) v(n306) v(n710) v(n712) v(n288) v(n714) v(n199) v(n271) v(n193) v(n721) v(n723) v(n370) v(n344) v(n336) v(n337) v(n300) v(n733) v(n243) v(n296) v(n241) v(n740) v(n742) v(n253) v(n233) v(n213) v(n362) v(n356) v(n313) v(n284) v(n756) v(n758) v(n249) v(n244) v(n223) v(n275) v(n266) v(n768) v(n770) v(n246) v(n772) v(n774) v(n364) v(n348) v(n343) v(n197) v(n240) v(n245) v(n786) v(n788) v(n328) v(n282) v(n235) v(n794) v(n796) v(n201) v(n325) v(n318) v(n237) v(n804) v(n806) v(n238) v(n225) v(n222) v(n308) v(n198) v(n816) v(n818) v(n262) v(n376) v(n374) v(n321) v(n317) v(n287) v(n286) v(n330) v(n834) v(n221) v(n195) v(n839) v(n841) v(n360) v(n366) v(n341) v(n327) v(n270) v(n232) v(n853) v(n855) v(n205) v(n315) v(n276) v(n211) v(n863) v(n865) v(n204) v(n867) v(n869) v(n264) v(n340) v(n338) v(n302) v(n301) v(n879) v(n228) v(n194) v(n884) v(n886) v(n200) v(n331) v(n258) v(n277) v(n273) v(n896) v(n214) v(n252) v(n901) v(n903) v(n230) v(n905) v(n907) v(n373) v(n347) v(n339) v(n365) v(n247) v(n917) v(n919) v(n372) v(n220) v(n363) v(n334) v(n927) v(n265) v(n354) v(n312) v(n309) v(n936) v(n219) v(n349) v(n278) v(n943) v(n250) v(n281) v(n283) v(n226) v(n952) v(n954) v(n350) v(n280) v(n958) v(n960) v(n190) v(n962) v(n964) v(n361) v(n333) v(n316) v(n970) v(n192) v(n279) v(n975) v(n256) v(n311) v(n254) v(n251) v(n202) v(n208) v(n988) v(n990) v(n319) v(n295) v(n212) v(n996) v(n998) v(n274) v(n358) v(n304) v(n303) v(n255) v(n1008) v(n1010) v(n210) v(n1012) v(n1014) v(n267) v(n263) v(n1018) v(n1020) v(n346) v(n1022) v(n1024) v(n293) v(n1026) v(n285) v(n196) v(n1031) v(n1033) v(n272) v(n257) v(n1037) v(n1039) v(n224) v(n1041) v(n1043) v(n380) v(n381) v(n382) v(n383) v(n384) v(n385) v(n386) v(n387) v(n388) v(n389) v(n390) v(n391) v(n392) v(n393) v(n394) v(n715) v(n396) v(n397) v(n398) v(n399) v(n400) v(n737) v(n402) v(n403) v(n404) v(n405) v(n406) v(n407) v(n408) v(n409) v(n410) v(n411) v(n412) v(n413) v(n414) v(n415) v(n416) v(n417) v(n418) v(n419) v(n420) v(n421) v(n687) v(n423) v(n424) v(n425) v(n426) v(n427) v(n428) v(n429) v(n430) v(n431) v(n432) v(n433) v(n434) v(n435) v(n436) v(n437) v(n438) v(n439) v(n742) v(n441) v(n442) v(n716) v(n444) v(n445) v(n446) v(n447) v(n448) v(n449) v(n450) v(n451) v(n452) v(n453) v(n454) v(n455) v(n456) v(n457) v(n458) v(n459) v(n460) v(n461) v(n462) v(n463) v(n464) v(n465) v(n466) v(n467) v(n468) v(n469) v(n470) v(n471) v(n472) v(n473) v(n474) v(n475) v(n476) v(n477) v(n478) v(n479) v(n480) v(n481) v(n482) v(n483) v(n484) v(n485) v(n486) v(n487) v(n488) v(n489) v(n490) v(n491) v(n728) v(n493) v(n494) v(n620) v(n496) v(n497) v(n498) v(n499) v(n500) v(n501) v(n502) v(n503) v(n504) v(n505) v(n506) v(n507) v(n508) v(n509) v(n510) v(n511) v(n512) v(n513) v(n514) v(n515) v(n516) v(n618) v(n518) v(n519) v(n520) v(n521) v(n522) v(n523) v(n524) v(n525) v(n526) v(n527) v(n528) v(n529) v(n530) v(n531) v(n532) v(n533) v(n534) v(n535) v(n536) v(n537) v(n538) v(n740) v(n540) v(n541) v(n697) v(n543) v(n544) v(n545) v(n546) v(n547) v(n710) v(n549) v(n550) v(n551) v(n552) v(n553) v(n554) v(n555) v(n556) v(n557) v(n558) v(n746) v(n560) v(n561) v(n562) v(n563) v(n564) v(n565) v(n566) v(n567) v(n568) v(n569)
.end
