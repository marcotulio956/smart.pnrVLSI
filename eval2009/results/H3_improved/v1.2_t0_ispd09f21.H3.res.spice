* spice from ispd09f21.H3.res
.include /home/mark/smart.pnrVLSI/ispd09CNS_results/ispd09_benchmarks/tuned_45nm_HP.pm
.subckt inv0 in out vdd
m1  out in  vdd vdd   pmos l=45n w=14.6u
m2  out in  0   0     nmos l=45n w=10.0u
.ends inv0
.subckt inv1 in out vdd
m1  out in  vdd vdd   pmos l=45n w=2.0u
m2  out in  0   0     nmos l=45n w=1.37u
.ends inv1
c0 n0 0 0f
c1 n117 0 27.988f
c2 n118 0 29.2093f
c3 n119 0 38.0109f
c4 n120 0 25.986f
c5 n121 0 47.20305f
c6 n122 0 29.96745f
c7 n123 0 38.8339f
c8 n124 0 41.7724f
c9 n125 0 20.1693f
c10 n126 0 25.2195f
c11 n127 0 44.64885f
c12 n128 0 36.2633f
c13 n129 0 30.0156f
c14 n130 0 42.89275f
c15 n131 0 38.51925f
c16 n132 0 46.15915f
c17 n133 0 25.7467f
c18 n134 0 34.1385f
c19 n135 0 28.45435f
c20 n136 0 25.8854f
c21 n137 0 42.7493f
c22 n138 0 40.54745f
c23 n139 0 37.8733f
c24 n140 0 33.89015f
c25 n141 0 43.7148f
c26 n142 0 42.4114f
c27 n143 0 38.07045f
c28 n144 0 26.872f
c29 n145 0 33.6816f
c30 n146 0 43.63275f
c31 n147 0 44.63825f
c32 n148 0 47.33115f
c33 n149 0 48.56545f
c34 n150 0 47.0445f
c35 n151 0 34.7958f
c36 n152 0 10.03365f
c37 n153 0 48.54185f
c38 n154 0 32.531f
c39 n155 0 32.8627f
c40 n156 0 37.6968f
c41 n157 0 25.613f
c42 n158 0 49.99085f
c43 n159 0 23.625625f
c44 n160 0 44.203375f
c45 n161 0 46.0742f
c46 n162 0 36.8982f
c47 n163 0 27.8584f
c48 n164 0 14.49305f
c49 n165 0 0f
c50 n166 0 31.7872f
c51 n167 0 36.4762f
c52 n168 0 41.76f
c53 n169 0 35.0987f
c54 n170 0 49.6543f
c55 n171 0 49.4242f
c56 n172 0 34.17335f
c57 n173 0 48.8278f
c58 n174 0 41.49695f
c59 n175 0 0f
c60 n176 0 41.01945f
c61 n177 0 49.847175f
c62 n178 0 41.80335f
c63 n179 0 38.7653f
c64 n180 0 33.27505f
c65 n181 0 46.271875f
c66 n182 0 33.6471f
c67 n183 0 0f
c68 n184 0 37.87275f
c69 n185 0 30.7004f
c70 n186 0 47.5346f
c71 n187 0 39.8119f
c72 n188 0 0f
c73 n189 0 49.43305f
c74 n190 0 34.6462f
c75 n191 0 47.266025f
c76 n192 0 39.683375f
c77 n193 0 1.00685f
c78 n194 0 44.8773f
c79 n195 0 35.5027f
c80 n196 0 41.93525f
c81 n197 0 0f
c82 n198 0 35.156725f
c83 n199 0 39.44295f
c84 n200 0 43.435975f
c85 n201 0 39.0887f
c86 n202 0 46.61265f
c87 n203 0 0f
c88 n204 0 29.968675f
c89 n205 0 43.7489f
c90 n206 0 38.3918f
c91 n207 0 3.1277f
c92 n208 0 0f
c93 n209 0 45.03995f
c94 n210 0 41.37725f
c95 n211 0 46.67125f
c96 n212 0 46.16705f
c97 n213 0 48.18075f
c98 n214 0 46.2405f
c99 n215 0 0f
c100 n216 0 0f
c101 n217 0 0f
c102 n218 0 47.71185f
c103 n219 0 48.289225f
c104 n220 0 0f
c105 n221 0 47.1103f
c106 n222 0 0f
c107 n223 0 0f
c108 n224 0 44.376125f
c109 n225 0 45.7667f
c110 n226 0 46.5308f
c111 n227 0 44.8692f
c112 n228 0 46.3433f
c113 n229 0 41.45795f
c114 n230 0 0f
c115 n231 0 0f
c116 n232 0 49.564675f
c117 n351 0 49.5648f
c118 n352 0 39.6836f
c119 n354 0 46.2722f
c120 n356 0 48.2895f
c121 n357 0 46.5314f
c122 n358 0 29.9689f
c123 n360 0 46.241f
c124 n361 0 44.3768f
c125 n362 0 44.8777f
c126 n363 0 48.181f
c127 n364 0 33.6473f
c128 n365 0 46.1671f
c129 n367 0 43.63275f
c130 n368 0 0f
c131 n369 0 48.8311f
c132 n370 0 0f
c133 n371 0 48.8311f
c134 n372 0 47.3313f
c135 n373 0 47.0447f
c136 n374 0 27.6904f
c137 n375 0 27.6904f
c138 n376 0 27.2605f
c139 n377 0 27.2605f
c140 n378 0 42.4114f
c141 n379 0 49.4243f
c142 n380 0 0f
c143 n381 0 35.3404f
c144 n382 0 14.49305f
c145 n383 0 28.0938f
c146 n384 0 28.0938f
c147 n385 0 0f
c148 n386 0 42.2948f
c149 n387 0 0f
c150 n388 0 42.2948f
c151 n389 0 39.8119f
c152 n390 0 41.8034f
c153 n391 0 36.6857f
c154 n392 0 36.6857f
c155 n393 0 40.5476f
c156 n394 0 32.5312f
c157 n395 0 0f
c158 n396 0 26.052f
c159 n397 0 0f
c160 n398 0 26.0521f
c161 n399 0 0f
c162 n400 0 36.0711f
c163 n401 0 0f
c164 n402 0 36.0711f
c165 n403 0 35.1568f
c166 n404 0 43.4361f
c167 n406 0 44.63825f
c168 n407 0 28.6251f
c169 n408 0 28.6251f
c170 n409 0 47.2913f
c171 n410 0 38.7654f
c172 n411 0 0f
c173 n412 0 36.4344f
c174 n413 0 0f
c175 n414 0 36.4343f
c176 n415 0 46.0744f
c177 n416 0 49.43305f
c178 n417 0 40.3105f
c179 n418 0 41.01945f
c180 n419 0 0f
c181 n420 0 39.9559f
c182 n421 0 33.89015f
c183 n422 0 46.0216f
c184 n423 0 46.0216f
c185 n424 0 39.1079f
c186 n425 0 30.0156f
c187 n426 0 0f
c188 n427 0 48.20005f
c189 n428 0 0f
c190 n429 0 48.20005f
c191 n430 0 37.8728f
c192 n431 0 35.5031f
c193 n432 0 42.8929f
c194 n433 0 49.6543f
c195 n434 0 0f
c196 n435 0 42.7567f
c197 n436 0 44.64885f
c198 n437 0 40.86455f
c199 n438 0 40.86455f
c200 n439 0 0f
c201 n440 0 49.38205f
c202 n441 0 0f
c203 n442 0 49.38205f
c204 n443 0 36.8983f
c205 n444 0 34.7959f
c206 n445 0 0f
c207 n446 0 29.2333f
c208 n447 0 0f
c209 n448 0 29.2333f
c210 n449 0 0f
c211 n450 0 27.1309f
c212 n451 0 0f
c213 n452 0 27.1309f
c214 n453 0 38.0111f
c215 n456 0 41.4973f
c216 n457 0 25.2195f
c217 n458 0 29.2095f
c218 n459 0 0f
c219 n460 0 38.00015f
c220 n461 0 0f
c221 n462 0 38.00015f
c222 n463 0 0f
c223 n464 0 45.97995f
c224 n465 0 0f
c225 n466 0 45.97995f
c226 n467 0 42.6546f
c227 n469 0 41.4581f
c228 n470 0 46.3444f
c229 n471 0 41.3777f
c230 n472 0 31.7872f
c231 n473 0 39.0888f
c232 n474 0 38.392f
c233 n475 0 48.5656f
c234 n476 0 36.2636f
c235 n477 0 0f
c236 n478 0 42.1678f
c237 n479 0 0f
c238 n480 0 42.1678f
c239 n481 0 0f
c240 n482 0 26.9137f
c241 n483 0 0f
c242 n484 0 26.9137f
c243 n485 0 48.542f
c244 n486 0 34.1734f
c245 n487 0 0f
c246 n488 0 46.34765f
c247 n489 0 0f
c248 n490 0 46.34765f
c249 n491 0 0f
c250 n492 0 25.8921f
c251 n493 0 0f
c252 n494 0 25.892f
c253 n495 0 0f
c254 n496 0 41.0496f
c255 n497 0 3.1277f
c256 n498 0 25.6131f
c257 n499 0 47.5346f
c258 n500 0 34.1385f
c259 n501 0 0f
c260 n502 0 37.8454f
c261 n503 0 45.25885f
c262 n504 0 45.25885f
c263 n505 0 28.4545f
c264 n506 0 27.8585f
c265 n507 0 27.0638f
c266 n508 0 27.0638f
c267 n509 0 26.4678f
c268 n510 0 26.4678f
c269 n512 0 37.8735f
c270 n513 0 0f
c271 n514 0 48.8752f
c272 n515 0 29.9677f
c273 n516 0 37.8152f
c274 n517 0 37.8152f
c275 n518 0 44.8692f
c276 n519 0 45.7668f
c277 n520 0 46.6717f
c278 n521 0 49.8473f
c279 n523 0 23.625625f
c280 n524 0 25.0462f
c281 n525 0 25.0462f
c282 n526 0 41.8916f
c283 n528 0 44.2035f
c284 n529 0 47.2664f
c285 n530 0 45.25785f
c286 n532 0 0f
c287 n533 0 44.616f
c288 n534 0 36.4763f
c289 n535 0 30.4477f
c290 n536 0 30.4477f
c291 n537 0 26.872f
c292 n538 0 25.8855f
c293 n539 0 0f
c294 n540 0 46.97035f
c295 n541 0 0f
c296 n542 0 46.97035f
c297 n543 0 0f
c298 n544 0 44.99725f
c299 n545 0 0f
c300 n546 0 44.99725f
c301 n548 0 10.03365f
c302 n549 0 49.63575f
c303 n550 0 49.63575f
c304 n551 0 45.04f
c305 n552 0 46.6129f
c306 n553 0 47.2031f
c307 n554 0 38.5194f
c308 n555 0 25.8053f
c309 n556 0 25.8053f
c310 n557 0 34.243f
c311 n558 0 34.243f
c312 n559 0 39.4431f
c313 n560 0 43.715f
c314 n561 0 48.83575f
c315 n562 0 48.83575f
c316 n563 0 33.6982f
c317 n564 0 1.00685f
c318 n565 0 0f
c319 n566 0 33.3626f
c320 n567 0 25.7469f
c321 n568 0 48.59405f
c322 n569 0 48.59405f
c323 n570 0 47.7121f
c324 n572 0 0f
c325 n573 0 25.85855f
c326 n575 0 43.7494f
c327 n576 0 47.1104f
c328 n577 0 0f
c329 n578 0 45.6577f
c330 n579 0 34.6462f
c331 n580 0 49.9911f
c332 n581 0 33.27505f
c333 n582 0 42.7493f
c334 n583 0 35.0989f
c335 n584 0 27.7615f
c336 n585 0 27.7615f
c337 n586 0 40.2219f
c338 n587 0 40.2219f
c339 n588 0 0f
c340 n589 0 29.5068f
c341 n590 0 0f
c342 n591 0 29.5068f
c343 n592 0 41.9353f
c344 n593 0 37.6971f
c345 n594 0 25.9861f
c346 n595 0 46.15915f
c347 n596 0 0f
c348 n597 0 48.1461f
c349 n598 0 0f
c350 n599 0 48.1461f
c351 n600 0 0f
c352 n601 0 42.33315f
c353 n602 0 0f
c354 n603 0 42.33315f
c355 n604 0 38.0706f
c356 n605 0 30.7006f
c357 n606 0 0f
c358 n607 0 49.911f
c359 n608 0 41.76f
c360 n609 0 29.031f
c361 n610 0 29.0309f
c362 n611 0 0f
c363 n612 0 47.01115f
c364 n613 0 0f
c365 n614 0 47.01115f
c366 n615 0 0f
c367 n616 0 47.4721f
c368 n617 0 27.9882f
c369 n618 0 38.9679f
c370 n619 0 38.9679f
c371 n620 0 0f
c372 n621 0 31.1148f
c373 n622 0 0f
c374 n623 0 31.1148f
c375 n624 0 38.8339f
c376 n625 0 32.8627f
c377 n626 0 27.182f
c378 n627 0 27.1821f
c379 n628 0 42.4216f
c380 n629 0 42.4216f
c381 n630 0 33.6816f
c382 n631 0 48.8278f
c383 n632 0 0f
c384 n633 0 39.7492f
c385 n634 0 41.7724f
c386 n635 0 37.7258f
c387 n636 0 37.7258f
c388 n637 0 0f
c389 n638 0 30.4815f
c390 n639 0 20.1693f
c391 n640 0 40.7935f
c392 n641 0 40.7935f
c393 n234 0 57.6856f
c394 n235 0 98.0711f
c395 n236 0 55.0711f
c396 n237 0 68.7567f
c397 n238 0 68.86455f
c398 n239 0 84.86455f
c399 n240 0 47.13085f
c400 n241 0 78.13085f
c401 n242 0 71.20005f
c402 n243 0 83.20005f
c403 n244 0 74.10775f
c404 n245 0 89.43415f
c405 n246 0 77.43425f
c406 n247 0 51.6856f
c407 n248 0 80.05195f
c408 n249 0 48.05185f
c409 n250 0 62.3401f
c410 n251 0 80.38205f
c411 n252 0 81.38205f
c412 n253 0 89.23325f
c413 n254 0 73.23325f
c414 n255 0 61.3102f
c415 n256 0 77.0216f
c416 n257 0 53.0216f
c417 n258 0 66.6248f
c418 n259 0 55.6248f
c419 n260 0 51.2948f
c420 n261 0 80.2948f
c421 n262 0 90.09365f
c422 n263 0 50.09365f
c423 n264 0 60.7258f
c424 n265 0 77.7258f
c425 n266 0 50.4813f
c426 n267 0 65.4216f
c427 n268 0 67.4216f
c428 n269 0 69.95585f
c429 n270 0 81.25885f
c430 n271 0 96.25885f
c431 n272 0 83.29075f
c432 n273 0 59.2604f
c433 n274 0 46.2604f
c434 n275 0 94.8311f
c435 n276 0 81.8311f
c436 n277 0 58.749f
c437 n278 0 45.7935f
c438 n279 0 67.7935f
c439 n280 0 55.182f
c440 n281 0 78.1819f
c441 n282 0 87.84505f
c442 n283 0 44.06365f
c443 n284 0 40.4677f
c444 n285 0 49.04935f
c445 n286 0 84.0308f
c446 n287 0 41.0309f
c447 n288 0 69.69035f
c448 n289 0 53.69035f
c449 n290 0 52.00015f
c450 n291 0 62.00015f
c451 n292 0 82.1148f
c452 n293 0 55.1148f
c453 n294 0 35.89185f
c454 n295 0 69.89195f
c455 n296 0 60.06365f
c456 n297 0 37.4677f
c457 n298 0 87.91355f
c458 n299 0 72.9108f
c459 n300 0 76.01115f
c460 n301 0 106.01115f
c461 n302 0 88.472f
c462 n303 0 53.97995f
c463 n304 0 57.97995f
c464 n305 0 59.6546f
c465 n306 0 104.87515f
c466 n307 0 96.34765f
c467 n308 0 65.34765f
c468 n309 0 88.1678f
c469 n310 0 68.1678f
c470 n311 0 71.91355f
c471 n312 0 72.1461f
c472 n313 0 63.1461f
c473 n314 0 42.85855f
c474 n315 0 46.9679f
c475 n316 0 47.9679f
c476 n317 0 92.83575f
c477 n318 0 87.83575f
c478 n319 0 62.8152f
c479 n320 0 48.8152f
c480 n321 0 103.97035f
c481 n322 0 73.97035f
c482 n323 0 63.04605f
c483 n324 0 61.891075f
c484 n325 0 84.33315f
c485 n326 0 79.33315f
c486 n327 0 91.5068f
c487 n328 0 78.5068f
c488 n329 0 92.59405f
c489 n330 0 91.59405f
c490 n331 0 42.6981f
c491 n332 0 98.63575f
c492 n333 0 65.63575f
c493 n334 0 65.99725f
c494 n335 0 105.99725f
c495 n336 0 32.04605f
c496 n337 0 51.44755f
c497 n338 0 85.65715f
c498 n339 0 61.2219f
c499 n340 0 88.2219f
c500 n341 0 45.7614f
c501 n342 0 39.7614f
c502 n343 0 50.36245f
c503 n344 0 39.243f
c504 n345 0 40.243f
c505 n346 0 41.8052f
c506 n347 0 39.8052f
c507 n348 0 82.61575f
c508 n349 0 80.25785f
c509 n350 0 83.44755f
c510 nSEG_NODE_525 0 99.1296f
c511 nSEG_NODE_526 0 99.1296f
c512 nSEG_NODE_527 0 99.1296f
c513 nSEG_NODE_528 0 99.1296f
c514 nSEG_NODE_529 0 99.1296f
c515 nSEG_NODE_530 0 99.1296f
c516 nSEG_NODE_531 0 99.1296f
c517 nSEG_NODE_532 0 99.1296f
c518 nSEG_NODE_533 0 99.1296f
c519 nSEG_NODE_534 0 99.1296f
c520 nSEG_NODE_535 0 99.1296f
c521 nSEG_NODE_536 0 99.1296f
c522 nSEG_NODE_537 0 99.1296f
c523 nSEG_NODE_538 0 99.1296f
c524 nSEG_NODE_539 0 99.1296f
c525 nSEG_NODE_540 0 99.1296f
c526 nSEG_NODE_541 0 99.1296f
c527 nSEG_NODE_542 0 99.1296f
c528 nSEG_NODE_543 0 99.1296f
c529 nSEG_NODE_544 0 99.129475f
c530 nSEG_NODE_545 0 79.3672f
c531 nSEG_NODE_546 0 79.366975f
c532 nSEG_NODE_547 0 92.5444f
c533 nSEG_NODE_548 0 92.544075f
c534 nSEG_NODE_549 0 96.579f
c535 nSEG_NODE_550 0 96.579f
c536 nSEG_NODE_551 0 96.579f
c537 nSEG_NODE_552 0 96.579f
c538 nSEG_NODE_553 0 96.578725f
c539 nSEG_NODE_554 0 93.0628f
c540 nSEG_NODE_555 0 93.0628f
c541 nSEG_NODE_556 0 93.0628f
c542 nSEG_NODE_557 0 93.0628f
c543 nSEG_NODE_558 0 93.0628f
c544 nSEG_NODE_559 0 93.0622f
c545 nSEG_NODE_560 0 59.937575f
c546 nSEG_NODE_561 0 92.482f
c547 nSEG_NODE_562 0 92.482f
c548 nSEG_NODE_563 0 92.482f
c549 nSEG_NODE_564 0 92.482f
c550 nSEG_NODE_565 0 92.482f
c551 nSEG_NODE_566 0 92.482f
c552 nSEG_NODE_567 0 92.482f
c553 nSEG_NODE_568 0 92.4815f
c554 nSEG_NODE_569 0 88.7536f
c555 nSEG_NODE_570 0 88.7536f
c556 nSEG_NODE_571 0 88.7536f
c557 nSEG_NODE_572 0 88.7536f
c558 nSEG_NODE_573 0 88.7536f
c559 nSEG_NODE_574 0 88.752925f
c560 nSEG_NODE_575 0 89.7554f
c561 nSEG_NODE_576 0 89.7554f
c562 nSEG_NODE_577 0 89.7554f
c563 nSEG_NODE_578 0 89.755f
c564 nSEG_NODE_579 0 96.362f
c565 nSEG_NODE_580 0 96.36175f
c566 nSEG_NODE_581 0 67.2944f
c567 nSEG_NODE_582 0 92.33415f
c568 nSEG_NODE_583 0 94.6626f
c569 nSEG_NODE_584 0 94.66245f
c570 nSEG_NODE_585 0 94.0894f
c571 nSEG_NODE_586 0 94.0892f
c572 nSEG_NODE_587 0 55.38075f
c573 nSEG_NODE_588 0 55.38075f
c574 nSEG_NODE_589 0 54.5209f
c575 nSEG_NODE_590 0 54.5209f
c576 nSEG_NODE_591 0 84.8228f
c577 nSEG_NODE_592 0 84.8228f
c578 nSEG_NODE_593 0 98.8485f
c579 nSEG_NODE_594 0 70.6805f
c580 nSEG_NODE_595 0 56.18745f
c581 nSEG_NODE_596 0 56.18745f
c582 nSEG_NODE_597 0 83.60675f
c583 nSEG_NODE_598 0 73.3713f
c584 nSEG_NODE_599 0 73.3713f
c585 nSEG_NODE_600 0 81.09505f
c586 nSEG_NODE_601 0 65.0622f
c587 nSEG_NODE_602 0 52.10395f
c588 nSEG_NODE_603 0 52.10395f
c589 nSEG_NODE_604 0 70.3136f
c590 nSEG_NODE_605 0 70.313525f
c591 nSEG_NODE_606 0 86.8722f
c592 nSEG_NODE_607 0 86.872075f
c593 nSEG_NODE_608 0 57.2499f
c594 nSEG_NODE_609 0 57.2499f
c595 nSEG_NODE_610 0 94.5826f
c596 nSEG_NODE_611 0 94.5826f
c597 nSEG_NODE_612 0 94.58205f
c598 nSEG_NODE_613 0 77.5308f
c599 nSEG_NODE_614 0 77.5307f
c600 nSEG_NODE_615 0 72.86855f
c601 nSEG_NODE_616 0 72.86855f
c602 nSEG_NODE_617 0 92.1486f
c603 nSEG_NODE_618 0 80.621f
c604 nSEG_NODE_619 0 80.6207f
c605 nSEG_NODE_620 0 79.91175f
c606 nSEG_NODE_621 0 78.21565f
c607 nSEG_NODE_622 0 75.7456f
c608 nSEG_NODE_623 0 75.74555f
c609 nSEG_NODE_624 0 71.0062f
c610 nSEG_NODE_625 0 71.0058f
c611 nSEG_NODE_626 0 85.78565f
c612 nSEG_NODE_627 0 85.5134f
c613 nSEG_NODE_628 0 73.7965f
c614 nSEG_NODE_629 0 69.5917f
c615 nSEG_NODE_630 0 58.46655f
c616 nSEG_NODE_631 0 58.46655f
c617 nSEG_NODE_632 0 54.26175f
c618 nSEG_NODE_633 0 54.26175f
c619 nSEG_NODE_634 0 76.0222f
c620 nSEG_NODE_635 0 76.022f
c621 nSEG_NODE_636 0 82.9946f
c622 nSEG_NODE_637 0 82.9946f
c623 nSEG_NODE_638 0 82.99425f
c624 nSEG_NODE_639 0 50.439f
c625 nSEG_NODE_640 0 58.4188f
c626 nSEG_NODE_641 0 82.9162f
c627 nSEG_NODE_642 0 82.9162f
c628 nSEG_NODE_643 0 82.9162f
c629 nSEG_NODE_644 0 82.91605f
c630 nSEG_NODE_645 0 92.6888f
c631 nSEG_NODE_646 0 92.6888f
c632 nSEG_NODE_647 0 92.6888f
c633 nSEG_NODE_648 0 92.6888f
c634 nSEG_NODE_649 0 92.6888f
c635 nSEG_NODE_650 0 92.6888f
c636 nSEG_NODE_651 0 92.6888f
c637 nSEG_NODE_652 0 92.6877f
c638 nSEG_NODE_653 0 82.7554f
c639 nSEG_NODE_654 0 82.7554f
c640 nSEG_NODE_655 0 82.75495f
c641 nSEG_NODE_656 0 63.5744f
c642 nSEG_NODE_657 0 78.1776f
c643 nSEG_NODE_658 0 78.1775f
c644 nSEG_NODE_659 0 76.784f
c645 nSEG_NODE_660 0 76.7838f
c646 nSEG_NODE_661 0 97.13105f
c647 nSEG_NODE_662 0 72.5272f
c648 nSEG_NODE_663 0 72.5269f
c649 nSEG_NODE_664 0 53.82725f
c650 nSEG_NODE_665 0 53.82725f
c651 nSEG_NODE_666 0 97.08385f
c652 nSEG_NODE_667 0 68.3468f
c653 nSEG_NODE_668 0 68.34675f
c654 nSEG_NODE_669 0 51.78395f
c655 nSEG_NODE_670 0 51.78395f
c656 nSEG_NODE_671 0 82.0992f
c657 nSEG_NODE_672 0 82.0992f
c658 nSEG_NODE_673 0 82.09895f
c659 nSEG_NODE_674 0 51.2261f
c660 nSEG_NODE_675 0 68.277f
c661 nSEG_NODE_676 0 75.6908f
c662 nSEG_NODE_677 0 75.69045f
c663 nSEG_NODE_678 0 56.90885f
c664 nSEG_NODE_679 0 55.7169f
c665 nSEG_NODE_680 0 54.12745f
c666 nSEG_NODE_681 0 54.12745f
c667 nSEG_NODE_682 0 52.9355f
c668 nSEG_NODE_683 0 52.9355f
c669 nSEG_NODE_684 0 75.747f
c670 nSEG_NODE_685 0 75.7468f
c671 nSEG_NODE_686 0 97.75035f
c672 nSEG_NODE_687 0 59.93515f
c673 nSEG_NODE_688 0 89.7384f
c674 nSEG_NODE_689 0 89.7384f
c675 nSEG_NODE_690 0 89.7384f
c676 nSEG_NODE_691 0 89.7384f
c677 nSEG_NODE_692 0 89.7384f
c678 nSEG_NODE_693 0 89.7384f
c679 nSEG_NODE_694 0 89.7384f
c680 nSEG_NODE_695 0 89.7384f
c681 nSEG_NODE_696 0 91.5336f
c682 nSEG_NODE_697 0 91.5336f
c683 nSEG_NODE_698 0 91.5336f
c684 nSEG_NODE_699 0 91.5336f
c685 nSEG_NODE_700 0 91.5335f
c686 nSEG_NODE_701 0 93.3434f
c687 nSEG_NODE_702 0 93.3434f
c688 nSEG_NODE_703 0 93.34295f
c689 nSEG_NODE_704 0 99.6946f
c690 nSEG_NODE_705 0 99.6946f
c691 nSEG_NODE_706 0 99.694475f
c692 nSEG_NODE_707 0 50.09225f
c693 nSEG_NODE_708 0 50.09225f
c694 nSEG_NODE_709 0 83.7832f
c695 nSEG_NODE_710 0 83.7832f
c696 nSEG_NODE_711 0 83.7832f
c697 nSEG_NODE_712 0 83.782675f
c698 nSEG_NODE_713 0 88.407f
c699 nSEG_NODE_714 0 88.406875f
c700 nSEG_NODE_715 0 94.5328f
c701 nSEG_NODE_716 0 94.532425f
c702 nSEG_NODE_717 0 89.232f
c703 nSEG_NODE_718 0 89.23175f
c704 nSEG_NODE_719 0 72.9525f
c705 nSEG_NODE_720 0 60.89525f
c706 nSEG_NODE_721 0 60.89525f
c707 nSEG_NODE_722 0 53.744f
c708 nSEG_NODE_723 0 51.7709f
c709 nSEG_NODE_724 0 90.08f
c710 nSEG_NODE_725 0 90.07995f
c711 nSEG_NODE_726 0 93.2258f
c712 nSEG_NODE_727 0 93.2258f
c713 nSEG_NODE_728 0 93.22555f
c714 nSEG_NODE_729 0 94.40615f
c715 nSEG_NODE_730 0 77.03865f
c716 nSEG_NODE_731 0 51.6105f
c717 nSEG_NODE_732 0 51.6105f
c718 nSEG_NODE_733 0 78.88605f
c719 nSEG_NODE_734 0 87.43f
c720 nSEG_NODE_735 0 87.4298f
c721 nSEG_NODE_736 0 67.3964f
c722 nSEG_NODE_737 0 67.3963f
c723 nSEG_NODE_738 0 66.7252f
c724 nSEG_NODE_739 0 66.72505f
c725 nSEG_NODE_740 0 51.4936f
c726 nSEG_NODE_741 0 95.4242f
c727 nSEG_NODE_742 0 95.42395f
c728 nSEG_NODE_743 0 87.4988f
c729 nSEG_NODE_744 0 87.4988f
c730 nSEG_NODE_745 0 87.4988f
c731 nSEG_NODE_746 0 87.4983f
c732 nSEG_NODE_747 0 94.2208f
c733 nSEG_NODE_748 0 94.2208f
c734 nSEG_NODE_749 0 94.2208f
c735 nSEG_NODE_750 0 94.2207f
c736 nSEG_NODE_751 0 91.3154f
c737 nSEG_NODE_752 0 91.3154f
c738 nSEG_NODE_753 0 91.3154f
c739 nSEG_NODE_754 0 91.31485f
c740 nSEG_NODE_755 0 69.2924f
c741 nSEG_NODE_756 0 99.98195f
c742 nSEG_NODE_757 0 85.4986f
c743 nSEG_NODE_758 0 70.1976f
c744 nSEG_NODE_759 0 55.5229f
c745 nSEG_NODE_760 0 55.5229f
c746 nSEG_NODE_761 0 59.0136f
c747 nSEG_NODE_762 0 59.0136f
c748 nSEG_NODE_763 0 83.87055f
c749 nSEG_NODE_764 0 75.3942f
c750 nSEG_NODE_765 0 75.3942f
c751 nSEG_NODE_766 0 75.3939f
c752 nSEG_NODE_767 0 51.9721f
c753 nSEG_NODE_768 0 76.1412f
c754 nSEG_NODE_769 0 76.14105f
c755 nSEG_NODE_770 0 61.401f
c756 nSEG_NODE_771 0 99.8218f
c757 nSEG_NODE_772 0 58.0618f
c758 nSEG_NODE_773 0 58.0618f
c759 nSEG_NODE_774 0 94.9441f
c760 nSEG_NODE_775 0 55.9762f
c761 nSEG_NODE_776 0 77.6678f
c762 nSEG_NODE_777 0 65.7254f
c763 nSEG_NODE_778 0 54.364f
c764 nSEG_NODE_779 0 54.364f
c765 nSEG_NODE_780 0 67.3632f
c766 nSEG_NODE_781 0 79.4982f
c767 nSEG_NODE_782 0 60.9628f
r0 n367 n146 43.63275
r1 n369 n275 48.8311
r2 n371 n276 48.8311
r3 n382 n164 14.49305
r4 n386 n260 42.2948
r5 n388 n261 42.2948
r6 n389 n187 39.8119
r7 n400 n235 36.0711
r8 n402 n236 36.0711
r9 n406 n147 44.63825
r10 n416 n189 49.43305
r11 n418 n176 41.01945
r12 n421 n140 33.89015
r13 n422 n256 46.0216
r14 n423 n257 46.0216
r15 n425 n129 30.0156
r16 n427 n242 48.20005
r17 n429 n243 48.20005
r18 n433 n170 49.6543
r19 n436 n127 44.64885
r20 n437 n238 40.86455
r21 n438 n239 40.86455
r22 n440 n251 49.38205
r23 n442 n252 49.38205
r24 n460 n290 38.00015
r25 n462 n291 38.00015
r26 n464 n303 45.97995
r27 n466 n304 45.97995
r28 n467 n305 42.6546
r29 n478 n309 42.1678
r30 n480 n310 42.1678
r31 n488 n308 46.34765
r32 n490 n307 46.34765
r33 n497 n207 3.1277
r34 n499 n186 47.5346
r35 n503 n270 45.25885
r36 n504 n271 45.25885
r37 n516 n319 37.8152
r38 n517 n320 37.8152
r39 n523 n159 23.625625
r40 n530 n349 45.25785
r41 n540 n321 46.97035
r42 n542 n322 46.97035
r43 n544 n334 44.99725
r44 n546 n335 44.99725
r45 n548 n152 10.03365
r46 n549 n332 49.63575
r47 n550 n333 49.63575
r48 n557 n344 34.243
r49 n558 n345 34.243
r50 n561 n317 48.83575
r51 n562 n318 48.83575
r52 n564 n193 1.00685
r53 n568 n329 48.59405
r54 n569 n330 48.59405
r55 n573 n314 25.85855
r56 n581 n180 33.27505
r57 n586 n339 40.2219
r58 n587 n340 40.2219
r59 n595 n132 46.15915
r60 n597 n312 48.1461
r61 n599 n313 48.1461
r62 n601 n325 42.33315
r63 n603 n326 42.33315
r64 n608 n168 41.76
r65 n612 n300 47.01115
r66 n614 n301 47.01115
r67 n618 n315 38.9679
r68 n619 n316 38.9679
r69 n621 n292 31.1148
r70 n623 n293 31.1148
r71 n628 n267 42.4216
r72 n629 n268 42.4216
r73 n631 n173 48.8278
r74 n634 n124 41.7724
r75 n635 n264 37.7258
r76 n636 n265 37.7258
r77 n639 n125 20.1693
r78 n640 n278 40.7935
r79 n641 n279 40.7935
r80 n351 nSEG_NODE_525 49.5648
r81 nSEG_NODE_525 nSEG_NODE_526 49.5648
r82 nSEG_NODE_526 nSEG_NODE_527 49.5648
r83 nSEG_NODE_527 nSEG_NODE_528 49.5648
r84 nSEG_NODE_528 nSEG_NODE_529 49.5648
r85 nSEG_NODE_529 nSEG_NODE_530 49.5648
r86 nSEG_NODE_530 nSEG_NODE_531 49.5648
r87 nSEG_NODE_531 nSEG_NODE_532 49.5648
r88 nSEG_NODE_532 nSEG_NODE_533 49.5648
r89 nSEG_NODE_533 nSEG_NODE_534 49.5648
r90 nSEG_NODE_534 nSEG_NODE_535 49.5648
r91 nSEG_NODE_535 nSEG_NODE_536 49.5648
r92 nSEG_NODE_536 nSEG_NODE_537 49.5648
r93 nSEG_NODE_537 nSEG_NODE_538 49.5648
r94 nSEG_NODE_538 nSEG_NODE_539 49.5648
r95 nSEG_NODE_539 nSEG_NODE_540 49.5648
r96 nSEG_NODE_540 nSEG_NODE_541 49.5648
r97 nSEG_NODE_541 nSEG_NODE_542 49.5648
r98 nSEG_NODE_542 nSEG_NODE_543 49.5648
r99 nSEG_NODE_543 nSEG_NODE_544 49.5648
r100 nSEG_NODE_544 n232 49.564675
r101 n352 nSEG_NODE_545 39.6836
r102 nSEG_NODE_545 nSEG_NODE_546 39.6836
r103 nSEG_NODE_546 n192 39.683375
r104 n354 nSEG_NODE_547 46.2722
r105 nSEG_NODE_547 nSEG_NODE_548 46.2722
r106 nSEG_NODE_548 n181 46.271875
r107 n356 nSEG_NODE_549 48.2895
r108 nSEG_NODE_549 nSEG_NODE_550 48.2895
r109 nSEG_NODE_550 nSEG_NODE_551 48.2895
r110 nSEG_NODE_551 nSEG_NODE_552 48.2895
r111 nSEG_NODE_552 nSEG_NODE_553 48.2895
r112 nSEG_NODE_553 n219 48.289225
r113 n357 nSEG_NODE_554 46.5314
r114 nSEG_NODE_554 nSEG_NODE_555 46.5314
r115 nSEG_NODE_555 nSEG_NODE_556 46.5314
r116 nSEG_NODE_556 nSEG_NODE_557 46.5314
r117 nSEG_NODE_557 nSEG_NODE_558 46.5314
r118 nSEG_NODE_558 nSEG_NODE_559 46.5314
r119 nSEG_NODE_559 n226 46.5308
r120 n358 nSEG_NODE_560 29.9689
r121 nSEG_NODE_560 n204 29.968675
r122 n360 nSEG_NODE_561 46.241
r123 nSEG_NODE_561 nSEG_NODE_562 46.241
r124 nSEG_NODE_562 nSEG_NODE_563 46.241
r125 nSEG_NODE_563 nSEG_NODE_564 46.241
r126 nSEG_NODE_564 nSEG_NODE_565 46.241
r127 nSEG_NODE_565 nSEG_NODE_566 46.241
r128 nSEG_NODE_566 nSEG_NODE_567 46.241
r129 nSEG_NODE_567 nSEG_NODE_568 46.241
r130 nSEG_NODE_568 n214 46.2405
r131 n361 nSEG_NODE_569 44.3768
r132 nSEG_NODE_569 nSEG_NODE_570 44.3768
r133 nSEG_NODE_570 nSEG_NODE_571 44.3768
r134 nSEG_NODE_571 nSEG_NODE_572 44.3768
r135 nSEG_NODE_572 nSEG_NODE_573 44.3768
r136 nSEG_NODE_573 nSEG_NODE_574 44.3768
r137 nSEG_NODE_574 n224 44.376125
r138 n362 nSEG_NODE_575 44.8777
r139 nSEG_NODE_575 nSEG_NODE_576 44.8777
r140 nSEG_NODE_576 nSEG_NODE_577 44.8777
r141 nSEG_NODE_577 nSEG_NODE_578 44.8777
r142 nSEG_NODE_578 n194 44.8773
r143 n363 nSEG_NODE_579 48.181
r144 nSEG_NODE_579 nSEG_NODE_580 48.181
r145 nSEG_NODE_580 n213 48.18075
r146 n364 nSEG_NODE_581 33.6473
r147 nSEG_NODE_581 n182 33.6471
r148 n365 nSEG_NODE_582 46.1671
r149 nSEG_NODE_582 n212 46.16705
r150 n372 nSEG_NODE_583 47.3313
r151 nSEG_NODE_583 nSEG_NODE_584 47.3313
r152 nSEG_NODE_584 n148 47.33115
r153 n373 nSEG_NODE_585 47.0447
r154 nSEG_NODE_585 nSEG_NODE_586 47.0447
r155 nSEG_NODE_586 n150 47.0445
r156 n374 nSEG_NODE_587 27.6904
r157 nSEG_NODE_587 n288 27.69035
r158 n375 nSEG_NODE_588 27.6904
r159 nSEG_NODE_588 n289 27.69035
r160 n376 nSEG_NODE_589 27.2605
r161 nSEG_NODE_589 n273 27.2604
r162 n377 nSEG_NODE_590 27.2605
r163 nSEG_NODE_590 n274 27.2604
r164 n378 nSEG_NODE_591 42.4114
r165 nSEG_NODE_591 nSEG_NODE_592 42.4114
r166 nSEG_NODE_592 n142 42.4114
r167 n379 nSEG_NODE_593 49.4243
r168 nSEG_NODE_593 n171 49.4242
r169 n381 nSEG_NODE_594 35.3404
r170 nSEG_NODE_594 n250 35.3401
r171 n383 nSEG_NODE_595 28.0938
r172 nSEG_NODE_595 n262 28.09365
r173 n384 nSEG_NODE_596 28.0938
r174 nSEG_NODE_596 n263 28.09365
r175 n390 nSEG_NODE_597 41.8034
r176 nSEG_NODE_597 n178 41.80335
r177 n391 nSEG_NODE_598 36.6857
r178 nSEG_NODE_598 n234 36.6856
r179 n392 nSEG_NODE_599 36.6857
r180 nSEG_NODE_599 n247 36.6856
r181 n393 nSEG_NODE_600 40.5476
r182 nSEG_NODE_600 n138 40.54745
r183 n394 nSEG_NODE_601 32.5312
r184 nSEG_NODE_601 n154 32.531
r185 n396 nSEG_NODE_602 26.052
r186 nSEG_NODE_602 n248 26.05195
r187 n398 nSEG_NODE_603 26.0521
r188 nSEG_NODE_603 n249 26.05185
r189 n403 nSEG_NODE_604 35.1568
r190 nSEG_NODE_604 nSEG_NODE_605 35.1568
r191 nSEG_NODE_605 n198 35.156725
r192 n404 nSEG_NODE_606 43.4361
r193 nSEG_NODE_606 nSEG_NODE_607 43.4361
r194 nSEG_NODE_607 n200 43.435975
r195 n407 nSEG_NODE_608 28.6251
r196 nSEG_NODE_608 n258 28.6248
r197 n408 nSEG_NODE_609 28.6251
r198 nSEG_NODE_609 n259 28.6248
r199 n409 nSEG_NODE_610 47.2913
r200 nSEG_NODE_610 nSEG_NODE_611 47.2913
r201 nSEG_NODE_611 nSEG_NODE_612 47.2913
r202 nSEG_NODE_612 n272 47.29075
r203 n410 nSEG_NODE_613 38.7654
r204 nSEG_NODE_613 nSEG_NODE_614 38.7654
r205 nSEG_NODE_614 n179 38.7653
r206 n412 nSEG_NODE_615 36.4344
r207 nSEG_NODE_615 n245 36.43415
r208 n414 nSEG_NODE_616 36.4343
r209 nSEG_NODE_616 n246 36.43425
r210 n415 nSEG_NODE_617 46.0744
r211 nSEG_NODE_617 n161 46.0742
r212 n417 nSEG_NODE_618 40.3105
r213 nSEG_NODE_618 nSEG_NODE_619 40.3105
r214 nSEG_NODE_619 n255 40.3102
r215 n420 nSEG_NODE_620 39.9559
r216 nSEG_NODE_620 n269 39.95585
r217 n424 nSEG_NODE_621 39.1079
r218 nSEG_NODE_621 n244 39.10775
r219 n430 nSEG_NODE_622 37.8728
r220 nSEG_NODE_622 nSEG_NODE_623 37.8728
r221 nSEG_NODE_623 n184 37.87275
r222 n431 nSEG_NODE_624 35.5031
r223 nSEG_NODE_624 nSEG_NODE_625 35.5031
r224 nSEG_NODE_625 n195 35.5027
r225 n432 nSEG_NODE_626 42.8929
r226 nSEG_NODE_626 n130 42.89275
r227 n435 nSEG_NODE_627 42.7567
r228 nSEG_NODE_627 n237 42.7567
r229 n443 nSEG_NODE_628 36.8983
r230 nSEG_NODE_628 n162 36.8982
r231 n444 nSEG_NODE_629 34.7959
r232 nSEG_NODE_629 n151 34.7958
r233 n446 nSEG_NODE_630 29.2333
r234 nSEG_NODE_630 n253 29.23325
r235 n448 nSEG_NODE_631 29.2333
r236 nSEG_NODE_631 n254 29.23325
r237 n450 nSEG_NODE_632 27.1309
r238 nSEG_NODE_632 n240 27.13085
r239 n452 nSEG_NODE_633 27.1309
r240 nSEG_NODE_633 n241 27.13085
r241 n453 nSEG_NODE_634 38.0111
r242 nSEG_NODE_634 nSEG_NODE_635 38.0111
r243 nSEG_NODE_635 n119 38.0109
r244 n456 nSEG_NODE_636 41.4973
r245 nSEG_NODE_636 nSEG_NODE_637 41.4973
r246 nSEG_NODE_637 nSEG_NODE_638 41.4973
r247 nSEG_NODE_638 n174 41.49695
r248 n457 nSEG_NODE_639 25.2195
r249 nSEG_NODE_639 n126 25.2195
r250 n458 nSEG_NODE_640 29.2095
r251 nSEG_NODE_640 n118 29.2093
r252 n469 nSEG_NODE_641 41.4581
r253 nSEG_NODE_641 nSEG_NODE_642 41.4581
r254 nSEG_NODE_642 nSEG_NODE_643 41.4581
r255 nSEG_NODE_643 nSEG_NODE_644 41.4581
r256 nSEG_NODE_644 n229 41.45795
r257 n470 nSEG_NODE_645 46.3444
r258 nSEG_NODE_645 nSEG_NODE_646 46.3444
r259 nSEG_NODE_646 nSEG_NODE_647 46.3444
r260 nSEG_NODE_647 nSEG_NODE_648 46.3444
r261 nSEG_NODE_648 nSEG_NODE_649 46.3444
r262 nSEG_NODE_649 nSEG_NODE_650 46.3444
r263 nSEG_NODE_650 nSEG_NODE_651 46.3444
r264 nSEG_NODE_651 nSEG_NODE_652 46.3444
r265 nSEG_NODE_652 n228 46.3433
r266 n471 nSEG_NODE_653 41.3777
r267 nSEG_NODE_653 nSEG_NODE_654 41.3777
r268 nSEG_NODE_654 nSEG_NODE_655 41.3777
r269 nSEG_NODE_655 n210 41.37725
r270 n472 nSEG_NODE_656 31.7872
r271 nSEG_NODE_656 n166 31.7872
r272 n473 nSEG_NODE_657 39.0888
r273 nSEG_NODE_657 nSEG_NODE_658 39.0888
r274 nSEG_NODE_658 n201 39.0887
r275 n474 nSEG_NODE_659 38.392
r276 nSEG_NODE_659 nSEG_NODE_660 38.392
r277 nSEG_NODE_660 n206 38.3918
r278 n475 nSEG_NODE_661 48.5656
r279 nSEG_NODE_661 n149 48.56545
r280 n476 nSEG_NODE_662 36.2636
r281 nSEG_NODE_662 nSEG_NODE_663 36.2636
r282 nSEG_NODE_663 n128 36.2633
r283 n482 nSEG_NODE_664 26.9137
r284 nSEG_NODE_664 n298 26.91355
r285 n484 nSEG_NODE_665 26.9137
r286 nSEG_NODE_665 n311 26.91355
r287 n485 nSEG_NODE_666 48.542
r288 nSEG_NODE_666 n153 48.54185
r289 n486 nSEG_NODE_667 34.1734
r290 nSEG_NODE_667 nSEG_NODE_668 34.1734
r291 nSEG_NODE_668 n172 34.17335
r292 n492 nSEG_NODE_669 25.8921
r293 nSEG_NODE_669 n294 25.89185
r294 n494 nSEG_NODE_670 25.892
r295 nSEG_NODE_670 n295 25.89195
r296 n496 nSEG_NODE_671 41.0496
r297 nSEG_NODE_671 nSEG_NODE_672 41.0496
r298 nSEG_NODE_672 nSEG_NODE_673 41.0496
r299 nSEG_NODE_673 n285 41.04935
r300 n498 nSEG_NODE_674 25.6131
r301 nSEG_NODE_674 n157 25.613
r302 n500 nSEG_NODE_675 34.1385
r303 nSEG_NODE_675 n134 34.1385
r304 n502 nSEG_NODE_676 37.8454
r305 nSEG_NODE_676 nSEG_NODE_677 37.8454
r306 nSEG_NODE_677 n282 37.84505
r307 n505 nSEG_NODE_678 28.4545
r308 nSEG_NODE_678 n135 28.45435
r309 n506 nSEG_NODE_679 27.8585
r310 nSEG_NODE_679 n163 27.8584
r311 n507 nSEG_NODE_680 27.0638
r312 nSEG_NODE_680 n283 27.06365
r313 n508 nSEG_NODE_681 27.0638
r314 nSEG_NODE_681 n296 27.06365
r315 n509 nSEG_NODE_682 26.4678
r316 nSEG_NODE_682 n284 26.4677
r317 n510 nSEG_NODE_683 26.4678
r318 nSEG_NODE_683 n297 26.4677
r319 n512 nSEG_NODE_684 37.8735
r320 nSEG_NODE_684 nSEG_NODE_685 37.8735
r321 nSEG_NODE_685 n139 37.8733
r322 n514 nSEG_NODE_686 48.8752
r323 nSEG_NODE_686 n306 48.87515
r324 n515 nSEG_NODE_687 29.9677
r325 nSEG_NODE_687 n122 29.96745
r326 n518 nSEG_NODE_688 44.8692
r327 nSEG_NODE_688 nSEG_NODE_689 44.8692
r328 nSEG_NODE_689 nSEG_NODE_690 44.8692
r329 nSEG_NODE_690 nSEG_NODE_691 44.8692
r330 nSEG_NODE_691 nSEG_NODE_692 44.8692
r331 nSEG_NODE_692 nSEG_NODE_693 44.8692
r332 nSEG_NODE_693 nSEG_NODE_694 44.8692
r333 nSEG_NODE_694 nSEG_NODE_695 44.8692
r334 nSEG_NODE_695 n227 44.8692
r335 n519 nSEG_NODE_696 45.7668
r336 nSEG_NODE_696 nSEG_NODE_697 45.7668
r337 nSEG_NODE_697 nSEG_NODE_698 45.7668
r338 nSEG_NODE_698 nSEG_NODE_699 45.7668
r339 nSEG_NODE_699 nSEG_NODE_700 45.7668
r340 nSEG_NODE_700 n225 45.7667
r341 n520 nSEG_NODE_701 46.6717
r342 nSEG_NODE_701 nSEG_NODE_702 46.6717
r343 nSEG_NODE_702 nSEG_NODE_703 46.6717
r344 nSEG_NODE_703 n211 46.67125
r345 n521 nSEG_NODE_704 49.8473
r346 nSEG_NODE_704 nSEG_NODE_705 49.8473
r347 nSEG_NODE_705 nSEG_NODE_706 49.8473
r348 nSEG_NODE_706 n177 49.847175
r349 n524 nSEG_NODE_707 25.0462
r350 nSEG_NODE_707 n323 25.04605
r351 n525 nSEG_NODE_708 25.0462
r352 nSEG_NODE_708 n336 25.04605
r353 n526 nSEG_NODE_709 41.8916
r354 nSEG_NODE_709 nSEG_NODE_710 41.8916
r355 nSEG_NODE_710 nSEG_NODE_711 41.8916
r356 nSEG_NODE_711 nSEG_NODE_712 41.8916
r357 nSEG_NODE_712 n324 41.891075
r358 n528 nSEG_NODE_713 44.2035
r359 nSEG_NODE_713 nSEG_NODE_714 44.2035
r360 nSEG_NODE_714 n160 44.203375
r361 n529 nSEG_NODE_715 47.2664
r362 nSEG_NODE_715 nSEG_NODE_716 47.2664
r363 nSEG_NODE_716 n191 47.266025
r364 n533 nSEG_NODE_717 44.616
r365 nSEG_NODE_717 nSEG_NODE_718 44.616
r366 nSEG_NODE_718 n348 44.61575
r367 n534 nSEG_NODE_719 36.4763
r368 nSEG_NODE_719 n167 36.4762
r369 n535 nSEG_NODE_720 30.4477
r370 nSEG_NODE_720 n337 30.44755
r371 n536 nSEG_NODE_721 30.4477
r372 nSEG_NODE_721 n350 30.44755
r373 n537 nSEG_NODE_722 26.872
r374 nSEG_NODE_722 n144 26.872
r375 n538 nSEG_NODE_723 25.8855
r376 nSEG_NODE_723 n136 25.8854
r377 n551 nSEG_NODE_724 45.04
r378 nSEG_NODE_724 nSEG_NODE_725 45.04
r379 nSEG_NODE_725 n209 45.03995
r380 n552 nSEG_NODE_726 46.6129
r381 nSEG_NODE_726 nSEG_NODE_727 46.6129
r382 nSEG_NODE_727 nSEG_NODE_728 46.6129
r383 nSEG_NODE_728 n202 46.61265
r384 n553 nSEG_NODE_729 47.2031
r385 nSEG_NODE_729 n121 47.20305
r386 n554 nSEG_NODE_730 38.5194
r387 nSEG_NODE_730 n131 38.51925
r388 n555 nSEG_NODE_731 25.8053
r389 nSEG_NODE_731 n346 25.8052
r390 n556 nSEG_NODE_732 25.8053
r391 nSEG_NODE_732 n347 25.8052
r392 n559 nSEG_NODE_733 39.4431
r393 nSEG_NODE_733 n199 39.44295
r394 n560 nSEG_NODE_734 43.715
r395 nSEG_NODE_734 nSEG_NODE_735 43.715
r396 nSEG_NODE_735 n141 43.7148
r397 n563 nSEG_NODE_736 33.6982
r398 nSEG_NODE_736 nSEG_NODE_737 33.6982
r399 nSEG_NODE_737 n331 33.6981
r400 n566 nSEG_NODE_738 33.3626
r401 nSEG_NODE_738 nSEG_NODE_739 33.3626
r402 nSEG_NODE_739 n343 33.36245
r403 n567 nSEG_NODE_740 25.7469
r404 nSEG_NODE_740 n133 25.7467
r405 n570 nSEG_NODE_741 47.7121
r406 nSEG_NODE_741 nSEG_NODE_742 47.7121
r407 nSEG_NODE_742 n218 47.71185
r408 n575 nSEG_NODE_743 43.7494
r409 nSEG_NODE_743 nSEG_NODE_744 43.7494
r410 nSEG_NODE_744 nSEG_NODE_745 43.7494
r411 nSEG_NODE_745 nSEG_NODE_746 43.7494
r412 nSEG_NODE_746 n205 43.7489
r413 n576 nSEG_NODE_747 47.1104
r414 nSEG_NODE_747 nSEG_NODE_748 47.1104
r415 nSEG_NODE_748 nSEG_NODE_749 47.1104
r416 nSEG_NODE_749 nSEG_NODE_750 47.1104
r417 nSEG_NODE_750 n221 47.1103
r418 n578 nSEG_NODE_751 45.6577
r419 nSEG_NODE_751 nSEG_NODE_752 45.6577
r420 nSEG_NODE_752 nSEG_NODE_753 45.6577
r421 nSEG_NODE_753 nSEG_NODE_754 45.6577
r422 nSEG_NODE_754 n338 45.65715
r423 n579 nSEG_NODE_755 34.6462
r424 nSEG_NODE_755 n190 34.6462
r425 n580 nSEG_NODE_756 49.9911
r426 nSEG_NODE_756 n158 49.99085
r427 n582 nSEG_NODE_757 42.7493
r428 nSEG_NODE_757 n137 42.7493
r429 n583 nSEG_NODE_758 35.0989
r430 nSEG_NODE_758 n169 35.0987
r431 n584 nSEG_NODE_759 27.7615
r432 nSEG_NODE_759 n341 27.7614
r433 n585 nSEG_NODE_760 27.7615
r434 nSEG_NODE_760 n342 27.7614
r435 n589 nSEG_NODE_761 29.5068
r436 nSEG_NODE_761 n327 29.5068
r437 n591 nSEG_NODE_762 29.5068
r438 nSEG_NODE_762 n328 29.5068
r439 n592 nSEG_NODE_763 41.9353
r440 nSEG_NODE_763 n196 41.93525
r441 n593 nSEG_NODE_764 37.6971
r442 nSEG_NODE_764 nSEG_NODE_765 37.6971
r443 nSEG_NODE_765 nSEG_NODE_766 37.6971
r444 nSEG_NODE_766 n156 37.6968
r445 n594 nSEG_NODE_767 25.9861
r446 nSEG_NODE_767 n120 25.986
r447 n604 nSEG_NODE_768 38.0706
r448 nSEG_NODE_768 nSEG_NODE_769 38.0706
r449 nSEG_NODE_769 n143 38.07045
r450 n605 nSEG_NODE_770 30.7006
r451 nSEG_NODE_770 n185 30.7004
r452 n607 nSEG_NODE_771 49.911
r453 nSEG_NODE_771 n299 49.9108
r454 n609 nSEG_NODE_772 29.031
r455 nSEG_NODE_772 n286 29.0308
r456 n610 nSEG_NODE_773 29.0309
r457 nSEG_NODE_773 n287 29.0309
r458 n616 nSEG_NODE_774 47.4721
r459 nSEG_NODE_774 n302 47.472
r460 n617 nSEG_NODE_775 27.9882
r461 nSEG_NODE_775 n117 27.988
r462 n624 nSEG_NODE_776 38.8339
r463 nSEG_NODE_776 n123 38.8339
r464 n625 nSEG_NODE_777 32.8627
r465 nSEG_NODE_777 n155 32.8627
r466 n626 nSEG_NODE_778 27.182
r467 nSEG_NODE_778 n280 27.182
r468 n627 nSEG_NODE_779 27.1821
r469 nSEG_NODE_779 n281 27.1819
r470 n630 nSEG_NODE_780 33.6816
r471 nSEG_NODE_780 n145 33.6816
r472 n633 nSEG_NODE_781 39.7492
r473 nSEG_NODE_781 n277 39.749
r474 n638 nSEG_NODE_782 30.4815
r475 nSEG_NODE_782 n266 30.4813
x0 gin n0 vdd inv0
x1 n0 n351 vdd inv0
x2 n232 n352 vdd inv0
x3 n232 n215 vdd inv0
x4 n215 n354 vdd inv0
x5 n215 n231 vdd inv0
x6 n231 n356 vdd inv0
x7 n231 n357 vdd inv0
x8 n226 n358 vdd inv0
x9 n226 n230 vdd inv0
x10 n230 n360 vdd inv0
x11 n230 n361 vdd inv0
x12 n224 n362 vdd inv0
x13 n224 n363 vdd inv0
x14 n213 n364 vdd inv0
x15 n213 n365 vdd inv0
x16 n212 n183 vdd inv0
x17 n212 n367 vdd inv0
x18 n146 n368 vdd inv0
x19 n368 n369 vdd inv0
x20 n146 n370 vdd inv0
x21 n370 n371 vdd inv0
x22 n183 n372 vdd inv0
x23 n183 n373 vdd inv0
x24 n150 n374 vdd inv0
x25 n150 n375 vdd inv0
x26 n148 n376 vdd inv0
x27 n148 n377 vdd inv0
x28 n182 n378 vdd inv0
x29 n182 n379 vdd inv0
x30 n171 n380 vdd inv0
x31 n380 n381 vdd inv0
x32 n171 n382 vdd inv0
x33 n164 n383 vdd inv0
x34 n164 n384 vdd inv0
x35 n142 n385 vdd inv0
x36 n385 n386 vdd inv0
x37 n142 n387 vdd inv0
x38 n387 n388 vdd inv0
x39 n194 n389 vdd inv0
x40 n194 n390 vdd inv0
x41 n178 n391 vdd inv0
x42 n178 n392 vdd inv0
x43 n187 n393 vdd inv0
x44 n187 n394 vdd inv0
x45 n154 n395 vdd inv0
x46 n395 n396 vdd inv0
x47 n154 n397 vdd inv0
x48 n397 n398 vdd inv0
x49 n138 n399 vdd inv0
x50 n399 n400 vdd inv0
x51 n138 n401 vdd inv0
x52 n401 n402 vdd inv0
x53 n214 n403 vdd inv0
x54 n214 n404 vdd inv0
x55 n200 n197 vdd inv0
x56 n200 n406 vdd inv0
x57 n147 n407 vdd inv0
x58 n147 n408 vdd inv0
x59 n197 n409 vdd inv0
x60 n197 n410 vdd inv0
x61 n179 n411 vdd inv0
x62 n411 n412 vdd inv0
x63 n179 n413 vdd inv0
x64 n413 n414 vdd inv0
x65 n198 n415 vdd inv0
x66 n198 n416 vdd inv0
x67 n189 n417 vdd inv0
x68 n189 n418 vdd inv0
x69 n176 n419 vdd inv0
x70 n419 n420 vdd inv0
x71 n176 n421 vdd inv0
x72 n140 n422 vdd inv0
x73 n140 n423 vdd inv0
x74 n161 n424 vdd inv0
x75 n161 n425 vdd inv0
x76 n129 n426 vdd inv0
x77 n426 n427 vdd inv0
x78 n129 n428 vdd inv0
x79 n428 n429 vdd inv0
x80 n204 n430 vdd inv0
x81 n204 n431 vdd inv0
x82 n195 n432 vdd inv0
x83 n195 n433 vdd inv0
x84 n170 n434 vdd inv0
x85 n434 n435 vdd inv0
x86 n170 n436 vdd inv0
x87 n127 n437 vdd inv0
x88 n127 n438 vdd inv0
x89 n130 n439 vdd inv0
x90 n439 n440 vdd inv0
x91 n130 n441 vdd inv0
x92 n441 n442 vdd inv0
x93 n184 n443 vdd inv0
x94 n184 n444 vdd inv0
x95 n151 n445 vdd inv0
x96 n445 n446 vdd inv0
x97 n151 n447 vdd inv0
x98 n447 n448 vdd inv0
x99 n162 n449 vdd inv0
x100 n449 n450 vdd inv0
x101 n162 n451 vdd inv0
x102 n451 n452 vdd inv0
x103 n219 n453 vdd inv0
x104 n219 n216 vdd inv0
x105 n216 n188 vdd inv0
x106 n216 n456 vdd inv0
x107 n174 n457 vdd inv0
x108 n174 n458 vdd inv0
x109 n118 n459 vdd inv0
x110 n459 n460 vdd inv0
x111 n118 n461 vdd inv0
x112 n461 n462 vdd inv0
x113 n126 n463 vdd inv0
x114 n463 n464 vdd inv0
x115 n126 n465 vdd inv0
x116 n465 n466 vdd inv0
x117 n188 n467 vdd inv0
x118 n188 n208 vdd inv0
x119 n208 n469 vdd inv0
x120 n208 n470 vdd inv0
x121 n228 n471 vdd inv0
x122 n228 n472 vdd inv0
x123 n166 n473 vdd inv0
x124 n166 n474 vdd inv0
x125 n206 n475 vdd inv0
x126 n206 n476 vdd inv0
x127 n128 n477 vdd inv0
x128 n477 n478 vdd inv0
x129 n128 n479 vdd inv0
x130 n479 n480 vdd inv0
x131 n149 n481 vdd inv0
x132 n481 n482 vdd inv0
x133 n149 n483 vdd inv0
x134 n483 n484 vdd inv0
x135 n201 n485 vdd inv0
x136 n201 n486 vdd inv0
x137 n172 n487 vdd inv0
x138 n487 n488 vdd inv0
x139 n172 n489 vdd inv0
x140 n489 n490 vdd inv0
x141 n153 n491 vdd inv0
x142 n491 n492 vdd inv0
x143 n153 n493 vdd inv0
x144 n493 n494 vdd inv0
x145 n210 n495 vdd inv0
x146 n495 n496 vdd inv0
x147 n210 n497 vdd inv0
x148 n207 n498 vdd inv0
x149 n207 n499 vdd inv0
x150 n186 n500 vdd inv0
x151 n186 n501 vdd inv0
x152 n501 n502 vdd inv0
x153 n134 n503 vdd inv0
x154 n134 n504 vdd inv0
x155 n157 n505 vdd inv0
x156 n157 n506 vdd inv0
x157 n163 n507 vdd inv0
x158 n163 n508 vdd inv0
x159 n135 n509 vdd inv0
x160 n135 n510 vdd inv0
x161 n229 n220 vdd inv0
x162 n229 n512 vdd inv0
x163 n139 n513 vdd inv0
x164 n513 n514 vdd inv0
x165 n139 n515 vdd inv0
x166 n122 n516 vdd inv0
x167 n122 n517 vdd inv0
x168 n220 n518 vdd inv0
x169 n220 n519 vdd inv0
x170 n225 n520 vdd inv0
x171 n225 n521 vdd inv0
x172 n177 n165 vdd inv0
x173 n177 n523 vdd inv0
x174 n159 n524 vdd inv0
x175 n159 n525 vdd inv0
x176 n165 n526 vdd inv0
x177 n165 n217 vdd inv0
x178 n217 n528 vdd inv0
x179 n217 n529 vdd inv0
x180 n191 n530 vdd inv0
x181 n191 n175 vdd inv0
x182 n175 n532 vdd inv0
x183 n532 n533 vdd inv0
x184 n175 n534 vdd inv0
x185 n167 n535 vdd inv0
x186 n167 n536 vdd inv0
x187 n160 n537 vdd inv0
x188 n160 n538 vdd inv0
x189 n136 n539 vdd inv0
x190 n539 n540 vdd inv0
x191 n136 n541 vdd inv0
x192 n541 n542 vdd inv0
x193 n144 n543 vdd inv0
x194 n543 n544 vdd inv0
x195 n144 n545 vdd inv0
x196 n545 n546 vdd inv0
x197 n211 n203 vdd inv0
x198 n211 n548 vdd inv0
x199 n152 n549 vdd inv0
x200 n152 n550 vdd inv0
x201 n203 n551 vdd inv0
x202 n203 n552 vdd inv0
x203 n202 n553 vdd inv0
x204 n202 n554 vdd inv0
x205 n131 n555 vdd inv0
x206 n131 n556 vdd inv0
x207 n121 n557 vdd inv0
x208 n121 n558 vdd inv0
x209 n209 n559 vdd inv0
x210 n209 n560 vdd inv0
x211 n141 n561 vdd inv0
x212 n141 n562 vdd inv0
x213 n199 n563 vdd inv0
x214 n199 n564 vdd inv0
x215 n193 n565 vdd inv0
x216 n565 n566 vdd inv0
x217 n193 n567 vdd inv0
x218 n133 n568 vdd inv0
x219 n133 n569 vdd inv0
x220 n227 n570 vdd inv0
x221 n227 n223 vdd inv0
x222 n223 n572 vdd inv0
x223 n572 n573 vdd inv0
x224 n223 n222 vdd inv0
x225 n222 n575 vdd inv0
x226 n222 n576 vdd inv0
x227 n221 n577 vdd inv0
x228 n577 n578 vdd inv0
x229 n221 n579 vdd inv0
x230 n190 n580 vdd inv0
x231 n190 n581 vdd inv0
x232 n180 n582 vdd inv0
x233 n180 n583 vdd inv0
x234 n169 n584 vdd inv0
x235 n169 n585 vdd inv0
x236 n137 n586 vdd inv0
x237 n137 n587 vdd inv0
x238 n158 n588 vdd inv0
x239 n588 n589 vdd inv0
x240 n158 n590 vdd inv0
x241 n590 n591 vdd inv0
x242 n205 n592 vdd inv0
x243 n205 n593 vdd inv0
x244 n156 n594 vdd inv0
x245 n156 n595 vdd inv0
x246 n132 n596 vdd inv0
x247 n596 n597 vdd inv0
x248 n132 n598 vdd inv0
x249 n598 n599 vdd inv0
x250 n120 n600 vdd inv0
x251 n600 n601 vdd inv0
x252 n120 n602 vdd inv0
x253 n602 n603 vdd inv0
x254 n196 n604 vdd inv0
x255 n196 n605 vdd inv0
x256 n185 n606 vdd inv0
x257 n606 n607 vdd inv0
x258 n185 n608 vdd inv0
x259 n168 n609 vdd inv0
x260 n168 n610 vdd inv0
x261 n143 n611 vdd inv0
x262 n611 n612 vdd inv0
x263 n143 n613 vdd inv0
x264 n613 n614 vdd inv0
x265 n218 n615 vdd inv0
x266 n615 n616 vdd inv0
x267 n218 n617 vdd inv0
x268 n117 n618 vdd inv0
x269 n117 n619 vdd inv0
x270 n119 n620 vdd inv0
x271 n620 n621 vdd inv0
x272 n119 n622 vdd inv0
x273 n622 n623 vdd inv0
x274 n181 n624 vdd inv0
x275 n181 n625 vdd inv0
x276 n155 n626 vdd inv0
x277 n155 n627 vdd inv0
x278 n123 n628 vdd inv0
x279 n123 n629 vdd inv0
x280 n192 n630 vdd inv0
x281 n192 n631 vdd inv0
x282 n173 n632 vdd inv0
x283 n632 n633 vdd inv0
x284 n173 n634 vdd inv0
x285 n124 n635 vdd inv0
x286 n124 n636 vdd inv0
x287 n145 n637 vdd inv0
x288 n637 n638 vdd inv0
x289 n145 n639 vdd inv0
x290 n125 n640 vdd inv0
x291 n125 n641 vdd inv0
*
vdd vdd 0 1.2
vdt gin 0 1.2 pwl(0n 0, 0.2n 0, 0.325n 1.2, 2n 1.2)
*
.ic v(gin)=0
.ic v(n0)=1.2
.ic v(n117)=1.2
.ic v(n118)=0
.ic v(n119)=0
.ic v(n120)=0
.ic v(n121)=1.2
.ic v(n122)=1.2
.ic v(n123)=1.2
.ic v(n124)=1.2
.ic v(n125)=1.2
.ic v(n126)=0
.ic v(n127)=1.2
.ic v(n128)=0
.ic v(n129)=0
.ic v(n130)=0
.ic v(n131)=1.2
.ic v(n132)=0
.ic v(n133)=1.2
.ic v(n134)=1.2
.ic v(n135)=1.2
.ic v(n136)=0
.ic v(n137)=1.2
.ic v(n138)=0
.ic v(n139)=0
.ic v(n140)=1.2
.ic v(n141)=1.2
.ic v(n142)=0
.ic v(n143)=0
.ic v(n144)=0
.ic v(n145)=0
.ic v(n146)=0
.ic v(n147)=1.2
.ic v(n148)=1.2
.ic v(n149)=0
.ic v(n150)=1.2
.ic v(n151)=0
.ic v(n152)=1.2
.ic v(n153)=0
.ic v(n154)=0
.ic v(n155)=1.2
.ic v(n156)=1.2
.ic v(n157)=0
.ic v(n158)=0
.ic v(n159)=1.2
.ic v(n160)=1.2
.ic v(n161)=1.2
.ic v(n162)=0
.ic v(n163)=1.2
.ic v(n164)=1.2
.ic v(n165)=1.2
.ic v(n166)=0
.ic v(n167)=1.2
.ic v(n168)=1.2
.ic v(n169)=1.2
.ic v(n170)=0
.ic v(n171)=0
.ic v(n172)=0
.ic v(n173)=0
.ic v(n174)=1.2
.ic v(n175)=0
.ic v(n176)=0
.ic v(n177)=0
.ic v(n178)=1.2
.ic v(n179)=0
.ic v(n180)=0
.ic v(n181)=0
.ic v(n182)=1.2
.ic v(n183)=0
.ic v(n184)=1.2
.ic v(n185)=0
.ic v(n186)=0
.ic v(n187)=1.2
.ic v(n188)=1.2
.ic v(n189)=1.2
.ic v(n190)=1.2
.ic v(n191)=1.2
.ic v(n192)=1.2
.ic v(n193)=0
.ic v(n194)=0
.ic v(n195)=1.2
.ic v(n196)=1.2
.ic v(n197)=1.2
.ic v(n198)=0
.ic v(n199)=1.2
.ic v(n200)=0
.ic v(n201)=1.2
.ic v(n202)=0
.ic v(n203)=1.2
.ic v(n204)=0
.ic v(n205)=0
.ic v(n206)=1.2
.ic v(n207)=1.2
.ic v(n208)=0
.ic v(n209)=0
.ic v(n210)=0
.ic v(n211)=0
.ic v(n212)=1.2
.ic v(n213)=0
.ic v(n214)=1.2
.ic v(n215)=1.2
.ic v(n216)=0
.ic v(n217)=0
.ic v(n218)=0
.ic v(n219)=1.2
.ic v(n220)=0
.ic v(n221)=0
.ic v(n222)=1.2
.ic v(n223)=0
.ic v(n224)=1.2
.ic v(n225)=1.2
.ic v(n226)=1.2
.ic v(n227)=1.2
.ic v(n228)=1.2
.ic v(n229)=1.2
.ic v(n230)=0
.ic v(n231)=0
.ic v(n232)=0
.ic v(n351)=0
.ic v(n352)=1.2
.ic v(n354)=0
.ic v(n356)=1.2
.ic v(n357)=1.2
.ic v(n358)=0
.ic v(n360)=1.2
.ic v(n361)=1.2
.ic v(n362)=0
.ic v(n363)=0
.ic v(n364)=1.2
.ic v(n365)=1.2
.ic v(n367)=0
.ic v(n368)=1.2
.ic v(n369)=0
.ic v(n370)=1.2
.ic v(n371)=0
.ic v(n372)=1.2
.ic v(n373)=1.2
.ic v(n374)=0
.ic v(n375)=0
.ic v(n376)=0
.ic v(n377)=0
.ic v(n378)=0
.ic v(n379)=0
.ic v(n380)=1.2
.ic v(n381)=0
.ic v(n382)=1.2
.ic v(n383)=0
.ic v(n384)=0
.ic v(n385)=1.2
.ic v(n386)=0
.ic v(n387)=1.2
.ic v(n388)=0
.ic v(n389)=1.2
.ic v(n390)=1.2
.ic v(n391)=0
.ic v(n392)=0
.ic v(n393)=0
.ic v(n394)=0
.ic v(n395)=1.2
.ic v(n396)=0
.ic v(n397)=1.2
.ic v(n398)=0
.ic v(n399)=1.2
.ic v(n400)=0
.ic v(n401)=1.2
.ic v(n402)=0
.ic v(n403)=0
.ic v(n404)=0
.ic v(n406)=1.2
.ic v(n407)=0
.ic v(n408)=0
.ic v(n409)=0
.ic v(n410)=0
.ic v(n411)=1.2
.ic v(n412)=0
.ic v(n413)=1.2
.ic v(n414)=0
.ic v(n415)=1.2
.ic v(n416)=1.2
.ic v(n417)=0
.ic v(n418)=0
.ic v(n419)=1.2
.ic v(n420)=0
.ic v(n421)=1.2
.ic v(n422)=0
.ic v(n423)=0
.ic v(n424)=0
.ic v(n425)=0
.ic v(n426)=1.2
.ic v(n427)=0
.ic v(n428)=1.2
.ic v(n429)=0
.ic v(n430)=1.2
.ic v(n431)=1.2
.ic v(n432)=0
.ic v(n433)=0
.ic v(n434)=1.2
.ic v(n435)=0
.ic v(n436)=1.2
.ic v(n437)=0
.ic v(n438)=0
.ic v(n439)=1.2
.ic v(n440)=0
.ic v(n441)=1.2
.ic v(n442)=0
.ic v(n443)=0
.ic v(n444)=0
.ic v(n445)=1.2
.ic v(n446)=0
.ic v(n447)=1.2
.ic v(n448)=0
.ic v(n449)=1.2
.ic v(n450)=0
.ic v(n451)=1.2
.ic v(n452)=0
.ic v(n453)=0
.ic v(n456)=1.2
.ic v(n457)=0
.ic v(n458)=0
.ic v(n459)=1.2
.ic v(n460)=0
.ic v(n461)=1.2
.ic v(n462)=0
.ic v(n463)=1.2
.ic v(n464)=0
.ic v(n465)=1.2
.ic v(n466)=0
.ic v(n467)=0
.ic v(n469)=1.2
.ic v(n470)=1.2
.ic v(n471)=0
.ic v(n472)=0
.ic v(n473)=1.2
.ic v(n474)=1.2
.ic v(n475)=0
.ic v(n476)=0
.ic v(n477)=1.2
.ic v(n478)=0
.ic v(n479)=1.2
.ic v(n480)=0
.ic v(n481)=1.2
.ic v(n482)=0
.ic v(n483)=1.2
.ic v(n484)=0
.ic v(n485)=0
.ic v(n486)=0
.ic v(n487)=1.2
.ic v(n488)=0
.ic v(n489)=1.2
.ic v(n490)=0
.ic v(n491)=1.2
.ic v(n492)=0
.ic v(n493)=1.2
.ic v(n494)=0
.ic v(n495)=1.2
.ic v(n496)=0
.ic v(n497)=1.2
.ic v(n498)=0
.ic v(n499)=0
.ic v(n500)=1.2
.ic v(n501)=1.2
.ic v(n502)=0
.ic v(n503)=0
.ic v(n504)=0
.ic v(n505)=1.2
.ic v(n506)=1.2
.ic v(n507)=0
.ic v(n508)=0
.ic v(n509)=0
.ic v(n510)=0
.ic v(n512)=0
.ic v(n513)=1.2
.ic v(n514)=0
.ic v(n515)=1.2
.ic v(n516)=0
.ic v(n517)=0
.ic v(n518)=1.2
.ic v(n519)=1.2
.ic v(n520)=0
.ic v(n521)=0
.ic v(n523)=1.2
.ic v(n524)=0
.ic v(n525)=0
.ic v(n526)=0
.ic v(n528)=1.2
.ic v(n529)=1.2
.ic v(n530)=0
.ic v(n532)=1.2
.ic v(n533)=0
.ic v(n534)=1.2
.ic v(n535)=0
.ic v(n536)=0
.ic v(n537)=0
.ic v(n538)=0
.ic v(n539)=1.2
.ic v(n540)=0
.ic v(n541)=1.2
.ic v(n542)=0
.ic v(n543)=1.2
.ic v(n544)=0
.ic v(n545)=1.2
.ic v(n546)=0
.ic v(n548)=1.2
.ic v(n549)=0
.ic v(n550)=0
.ic v(n551)=0
.ic v(n552)=0
.ic v(n553)=1.2
.ic v(n554)=1.2
.ic v(n555)=0
.ic v(n556)=0
.ic v(n557)=0
.ic v(n558)=0
.ic v(n559)=1.2
.ic v(n560)=1.2
.ic v(n561)=0
.ic v(n562)=0
.ic v(n563)=0
.ic v(n564)=0
.ic v(n565)=1.2
.ic v(n566)=0
.ic v(n567)=1.2
.ic v(n568)=0
.ic v(n569)=0
.ic v(n570)=0
.ic v(n572)=1.2
.ic v(n573)=0
.ic v(n575)=0
.ic v(n576)=0
.ic v(n577)=1.2
.ic v(n578)=0
.ic v(n579)=1.2
.ic v(n580)=0
.ic v(n581)=0
.ic v(n582)=1.2
.ic v(n583)=1.2
.ic v(n584)=0
.ic v(n585)=0
.ic v(n586)=0
.ic v(n587)=0
.ic v(n588)=1.2
.ic v(n589)=0
.ic v(n590)=1.2
.ic v(n591)=0
.ic v(n592)=1.2
.ic v(n593)=1.2
.ic v(n594)=0
.ic v(n595)=0
.ic v(n596)=1.2
.ic v(n597)=0
.ic v(n598)=1.2
.ic v(n599)=0
.ic v(n600)=1.2
.ic v(n601)=0
.ic v(n602)=1.2
.ic v(n603)=0
.ic v(n604)=0
.ic v(n605)=0
.ic v(n606)=1.2
.ic v(n607)=0
.ic v(n608)=1.2
.ic v(n609)=0
.ic v(n610)=0
.ic v(n611)=1.2
.ic v(n612)=0
.ic v(n613)=1.2
.ic v(n614)=0
.ic v(n615)=1.2
.ic v(n616)=0
.ic v(n617)=1.2
.ic v(n618)=0
.ic v(n619)=0
.ic v(n620)=1.2
.ic v(n621)=0
.ic v(n622)=1.2
.ic v(n623)=0
.ic v(n624)=1.2
.ic v(n625)=1.2
.ic v(n626)=0
.ic v(n627)=0
.ic v(n628)=0
.ic v(n629)=0
.ic v(n630)=0
.ic v(n631)=0
.ic v(n632)=1.2
.ic v(n633)=0
.ic v(n634)=1.2
.ic v(n635)=0
.ic v(n636)=0
.ic v(n637)=1.2
.ic v(n638)=0
.ic v(n639)=1.2
.ic v(n640)=0
.ic v(n641)=0
.ic v(n234)=0
.ic v(n235)=0
.ic v(n236)=0
.ic v(n237)=0
.ic v(n238)=0
.ic v(n239)=0
.ic v(n240)=0
.ic v(n241)=0
.ic v(n242)=0
.ic v(n243)=0
.ic v(n244)=0
.ic v(n245)=0
.ic v(n246)=0
.ic v(n247)=0
.ic v(n248)=0
.ic v(n249)=0
.ic v(n250)=0
.ic v(n251)=0
.ic v(n252)=0
.ic v(n253)=0
.ic v(n254)=0
.ic v(n255)=0
.ic v(n256)=0
.ic v(n257)=0
.ic v(n258)=0
.ic v(n259)=0
.ic v(n260)=0
.ic v(n261)=0
.ic v(n262)=0
.ic v(n263)=0
.ic v(n264)=0
.ic v(n265)=0
.ic v(n266)=0
.ic v(n267)=0
.ic v(n268)=0
.ic v(n269)=0
.ic v(n270)=0
.ic v(n271)=0
.ic v(n272)=0
.ic v(n273)=0
.ic v(n274)=0
.ic v(n275)=0
.ic v(n276)=0
.ic v(n277)=0
.ic v(n278)=0
.ic v(n279)=0
.ic v(n280)=0
.ic v(n281)=0
.ic v(n282)=0
.ic v(n283)=0
.ic v(n284)=0
.ic v(n285)=0
.ic v(n286)=0
.ic v(n287)=0
.ic v(n288)=0
.ic v(n289)=0
.ic v(n290)=0
.ic v(n291)=0
.ic v(n292)=0
.ic v(n293)=0
.ic v(n294)=0
.ic v(n295)=0
.ic v(n296)=0
.ic v(n297)=0
.ic v(n298)=0
.ic v(n299)=0
.ic v(n300)=0
.ic v(n301)=0
.ic v(n302)=0
.ic v(n303)=0
.ic v(n304)=0
.ic v(n305)=0
.ic v(n306)=0
.ic v(n307)=0
.ic v(n308)=0
.ic v(n309)=0
.ic v(n310)=0
.ic v(n311)=0
.ic v(n312)=0
.ic v(n313)=0
.ic v(n314)=0
.ic v(n315)=0
.ic v(n316)=0
.ic v(n317)=0
.ic v(n318)=0
.ic v(n319)=0
.ic v(n320)=0
.ic v(n321)=0
.ic v(n322)=0
.ic v(n323)=0
.ic v(n324)=0
.ic v(n325)=0
.ic v(n326)=0
.ic v(n327)=0
.ic v(n328)=0
.ic v(n329)=0
.ic v(n330)=0
.ic v(n331)=0
.ic v(n332)=0
.ic v(n333)=0
.ic v(n334)=0
.ic v(n335)=0
.ic v(n336)=0
.ic v(n337)=0
.ic v(n338)=0
.ic v(n339)=0
.ic v(n340)=0
.ic v(n341)=0
.ic v(n342)=0
.ic v(n343)=0
.ic v(n344)=0
.ic v(n345)=0
.ic v(n346)=0
.ic v(n347)=0
.ic v(n348)=0
.ic v(n349)=0
.ic v(n350)=0
.ic v(nSEG_NODE_525)=1.2
.ic v(nSEG_NODE_526)=1.2
.ic v(nSEG_NODE_527)=1.2
.ic v(nSEG_NODE_528)=1.2
.ic v(nSEG_NODE_529)=1.2
.ic v(nSEG_NODE_530)=1.2
.ic v(nSEG_NODE_531)=1.2
.ic v(nSEG_NODE_532)=1.2
.ic v(nSEG_NODE_533)=1.2
.ic v(nSEG_NODE_534)=1.2
.ic v(nSEG_NODE_535)=1.2
.ic v(nSEG_NODE_536)=1.2
.ic v(nSEG_NODE_537)=1.2
.ic v(nSEG_NODE_538)=1.2
.ic v(nSEG_NODE_539)=1.2
.ic v(nSEG_NODE_540)=1.2
.ic v(nSEG_NODE_541)=1.2
.ic v(nSEG_NODE_542)=1.2
.ic v(nSEG_NODE_543)=1.2
.ic v(nSEG_NODE_544)=1.2
.ic v(nSEG_NODE_545)=1.2
.ic v(nSEG_NODE_546)=1.2
.ic v(nSEG_NODE_547)=1.2
.ic v(nSEG_NODE_548)=1.2
.ic v(nSEG_NODE_549)=1.2
.ic v(nSEG_NODE_550)=1.2
.ic v(nSEG_NODE_551)=1.2
.ic v(nSEG_NODE_552)=1.2
.ic v(nSEG_NODE_553)=1.2
.ic v(nSEG_NODE_554)=1.2
.ic v(nSEG_NODE_555)=1.2
.ic v(nSEG_NODE_556)=1.2
.ic v(nSEG_NODE_557)=1.2
.ic v(nSEG_NODE_558)=1.2
.ic v(nSEG_NODE_559)=1.2
.ic v(nSEG_NODE_560)=1.2
.ic v(nSEG_NODE_561)=1.2
.ic v(nSEG_NODE_562)=1.2
.ic v(nSEG_NODE_563)=1.2
.ic v(nSEG_NODE_564)=1.2
.ic v(nSEG_NODE_565)=1.2
.ic v(nSEG_NODE_566)=1.2
.ic v(nSEG_NODE_567)=1.2
.ic v(nSEG_NODE_568)=1.2
.ic v(nSEG_NODE_569)=1.2
.ic v(nSEG_NODE_570)=1.2
.ic v(nSEG_NODE_571)=1.2
.ic v(nSEG_NODE_572)=1.2
.ic v(nSEG_NODE_573)=1.2
.ic v(nSEG_NODE_574)=1.2
.ic v(nSEG_NODE_575)=1.2
.ic v(nSEG_NODE_576)=1.2
.ic v(nSEG_NODE_577)=1.2
.ic v(nSEG_NODE_578)=1.2
.ic v(nSEG_NODE_579)=1.2
.ic v(nSEG_NODE_580)=1.2
.ic v(nSEG_NODE_581)=1.2
.ic v(nSEG_NODE_582)=1.2
.ic v(nSEG_NODE_583)=1.2
.ic v(nSEG_NODE_584)=1.2
.ic v(nSEG_NODE_585)=1.2
.ic v(nSEG_NODE_586)=1.2
.ic v(nSEG_NODE_587)=1.2
.ic v(nSEG_NODE_588)=1.2
.ic v(nSEG_NODE_589)=1.2
.ic v(nSEG_NODE_590)=1.2
.ic v(nSEG_NODE_591)=1.2
.ic v(nSEG_NODE_592)=1.2
.ic v(nSEG_NODE_593)=1.2
.ic v(nSEG_NODE_594)=1.2
.ic v(nSEG_NODE_595)=1.2
.ic v(nSEG_NODE_596)=1.2
.ic v(nSEG_NODE_597)=1.2
.ic v(nSEG_NODE_598)=1.2
.ic v(nSEG_NODE_599)=1.2
.ic v(nSEG_NODE_600)=1.2
.ic v(nSEG_NODE_601)=1.2
.ic v(nSEG_NODE_602)=1.2
.ic v(nSEG_NODE_603)=1.2
.ic v(nSEG_NODE_604)=1.2
.ic v(nSEG_NODE_605)=1.2
.ic v(nSEG_NODE_606)=1.2
.ic v(nSEG_NODE_607)=1.2
.ic v(nSEG_NODE_608)=1.2
.ic v(nSEG_NODE_609)=1.2
.ic v(nSEG_NODE_610)=1.2
.ic v(nSEG_NODE_611)=1.2
.ic v(nSEG_NODE_612)=1.2
.ic v(nSEG_NODE_613)=1.2
.ic v(nSEG_NODE_614)=1.2
.ic v(nSEG_NODE_615)=1.2
.ic v(nSEG_NODE_616)=1.2
.ic v(nSEG_NODE_617)=1.2
.ic v(nSEG_NODE_618)=1.2
.ic v(nSEG_NODE_619)=1.2
.ic v(nSEG_NODE_620)=1.2
.ic v(nSEG_NODE_621)=1.2
.ic v(nSEG_NODE_622)=1.2
.ic v(nSEG_NODE_623)=1.2
.ic v(nSEG_NODE_624)=1.2
.ic v(nSEG_NODE_625)=1.2
.ic v(nSEG_NODE_626)=1.2
.ic v(nSEG_NODE_627)=1.2
.ic v(nSEG_NODE_628)=1.2
.ic v(nSEG_NODE_629)=1.2
.ic v(nSEG_NODE_630)=1.2
.ic v(nSEG_NODE_631)=1.2
.ic v(nSEG_NODE_632)=1.2
.ic v(nSEG_NODE_633)=1.2
.ic v(nSEG_NODE_634)=1.2
.ic v(nSEG_NODE_635)=1.2
.ic v(nSEG_NODE_636)=1.2
.ic v(nSEG_NODE_637)=1.2
.ic v(nSEG_NODE_638)=1.2
.ic v(nSEG_NODE_639)=1.2
.ic v(nSEG_NODE_640)=1.2
.ic v(nSEG_NODE_641)=1.2
.ic v(nSEG_NODE_642)=1.2
.ic v(nSEG_NODE_643)=1.2
.ic v(nSEG_NODE_644)=1.2
.ic v(nSEG_NODE_645)=1.2
.ic v(nSEG_NODE_646)=1.2
.ic v(nSEG_NODE_647)=1.2
.ic v(nSEG_NODE_648)=1.2
.ic v(nSEG_NODE_649)=1.2
.ic v(nSEG_NODE_650)=1.2
.ic v(nSEG_NODE_651)=1.2
.ic v(nSEG_NODE_652)=1.2
.ic v(nSEG_NODE_653)=1.2
.ic v(nSEG_NODE_654)=1.2
.ic v(nSEG_NODE_655)=1.2
.ic v(nSEG_NODE_656)=1.2
.ic v(nSEG_NODE_657)=1.2
.ic v(nSEG_NODE_658)=1.2
.ic v(nSEG_NODE_659)=1.2
.ic v(nSEG_NODE_660)=1.2
.ic v(nSEG_NODE_661)=1.2
.ic v(nSEG_NODE_662)=1.2
.ic v(nSEG_NODE_663)=1.2
.ic v(nSEG_NODE_664)=1.2
.ic v(nSEG_NODE_665)=1.2
.ic v(nSEG_NODE_666)=1.2
.ic v(nSEG_NODE_667)=1.2
.ic v(nSEG_NODE_668)=1.2
.ic v(nSEG_NODE_669)=1.2
.ic v(nSEG_NODE_670)=1.2
.ic v(nSEG_NODE_671)=1.2
.ic v(nSEG_NODE_672)=1.2
.ic v(nSEG_NODE_673)=1.2
.ic v(nSEG_NODE_674)=1.2
.ic v(nSEG_NODE_675)=1.2
.ic v(nSEG_NODE_676)=1.2
.ic v(nSEG_NODE_677)=1.2
.ic v(nSEG_NODE_678)=1.2
.ic v(nSEG_NODE_679)=1.2
.ic v(nSEG_NODE_680)=1.2
.ic v(nSEG_NODE_681)=1.2
.ic v(nSEG_NODE_682)=1.2
.ic v(nSEG_NODE_683)=1.2
.ic v(nSEG_NODE_684)=1.2
.ic v(nSEG_NODE_685)=1.2
.ic v(nSEG_NODE_686)=1.2
.ic v(nSEG_NODE_687)=1.2
.ic v(nSEG_NODE_688)=1.2
.ic v(nSEG_NODE_689)=1.2
.ic v(nSEG_NODE_690)=1.2
.ic v(nSEG_NODE_691)=1.2
.ic v(nSEG_NODE_692)=1.2
.ic v(nSEG_NODE_693)=1.2
.ic v(nSEG_NODE_694)=1.2
.ic v(nSEG_NODE_695)=1.2
.ic v(nSEG_NODE_696)=1.2
.ic v(nSEG_NODE_697)=1.2
.ic v(nSEG_NODE_698)=1.2
.ic v(nSEG_NODE_699)=1.2
.ic v(nSEG_NODE_700)=1.2
.ic v(nSEG_NODE_701)=1.2
.ic v(nSEG_NODE_702)=1.2
.ic v(nSEG_NODE_703)=1.2
.ic v(nSEG_NODE_704)=1.2
.ic v(nSEG_NODE_705)=1.2
.ic v(nSEG_NODE_706)=1.2
.ic v(nSEG_NODE_707)=1.2
.ic v(nSEG_NODE_708)=1.2
.ic v(nSEG_NODE_709)=1.2
.ic v(nSEG_NODE_710)=1.2
.ic v(nSEG_NODE_711)=1.2
.ic v(nSEG_NODE_712)=1.2
.ic v(nSEG_NODE_713)=1.2
.ic v(nSEG_NODE_714)=1.2
.ic v(nSEG_NODE_715)=1.2
.ic v(nSEG_NODE_716)=1.2
.ic v(nSEG_NODE_717)=1.2
.ic v(nSEG_NODE_718)=1.2
.ic v(nSEG_NODE_719)=1.2
.ic v(nSEG_NODE_720)=1.2
.ic v(nSEG_NODE_721)=1.2
.ic v(nSEG_NODE_722)=1.2
.ic v(nSEG_NODE_723)=1.2
.ic v(nSEG_NODE_724)=1.2
.ic v(nSEG_NODE_725)=1.2
.ic v(nSEG_NODE_726)=1.2
.ic v(nSEG_NODE_727)=1.2
.ic v(nSEG_NODE_728)=1.2
.ic v(nSEG_NODE_729)=1.2
.ic v(nSEG_NODE_730)=1.2
.ic v(nSEG_NODE_731)=1.2
.ic v(nSEG_NODE_732)=1.2
.ic v(nSEG_NODE_733)=1.2
.ic v(nSEG_NODE_734)=1.2
.ic v(nSEG_NODE_735)=1.2
.ic v(nSEG_NODE_736)=1.2
.ic v(nSEG_NODE_737)=1.2
.ic v(nSEG_NODE_738)=1.2
.ic v(nSEG_NODE_739)=1.2
.ic v(nSEG_NODE_740)=1.2
.ic v(nSEG_NODE_741)=1.2
.ic v(nSEG_NODE_742)=1.2
.ic v(nSEG_NODE_743)=1.2
.ic v(nSEG_NODE_744)=1.2
.ic v(nSEG_NODE_745)=1.2
.ic v(nSEG_NODE_746)=1.2
.ic v(nSEG_NODE_747)=1.2
.ic v(nSEG_NODE_748)=1.2
.ic v(nSEG_NODE_749)=1.2
.ic v(nSEG_NODE_750)=1.2
.ic v(nSEG_NODE_751)=1.2
.ic v(nSEG_NODE_752)=1.2
.ic v(nSEG_NODE_753)=1.2
.ic v(nSEG_NODE_754)=1.2
.ic v(nSEG_NODE_755)=1.2
.ic v(nSEG_NODE_756)=1.2
.ic v(nSEG_NODE_757)=1.2
.ic v(nSEG_NODE_758)=1.2
.ic v(nSEG_NODE_759)=1.2
.ic v(nSEG_NODE_760)=1.2
.ic v(nSEG_NODE_761)=1.2
.ic v(nSEG_NODE_762)=1.2
.ic v(nSEG_NODE_763)=1.2
.ic v(nSEG_NODE_764)=1.2
.ic v(nSEG_NODE_765)=1.2
.ic v(nSEG_NODE_766)=1.2
.ic v(nSEG_NODE_767)=1.2
.ic v(nSEG_NODE_768)=1.2
.ic v(nSEG_NODE_769)=1.2
.ic v(nSEG_NODE_770)=1.2
.ic v(nSEG_NODE_771)=1.2
.ic v(nSEG_NODE_772)=1.2
.ic v(nSEG_NODE_773)=1.2
.ic v(nSEG_NODE_774)=1.2
.ic v(nSEG_NODE_775)=1.2
.ic v(nSEG_NODE_776)=1.2
.ic v(nSEG_NODE_777)=1.2
.ic v(nSEG_NODE_778)=1.2
.ic v(nSEG_NODE_779)=1.2
.ic v(nSEG_NODE_780)=1.2
.ic v(nSEG_NODE_781)=1.2
.ic v(nSEG_NODE_782)=1.2
*
.opti nopage temp=75
.width out=240
*
.tran 0.01n 2n 0.0n 0.01n
* .print tran v(gin) v(n0) v(n232) v(n215) v(n231) v(n226) v(n230) v(n224) v(n213) v(n212) v(n146) v(n368) v(n370) v(n183) v(n150) v(n148) v(n182) v(n171) v(n380) v(n164) v(n142) v(n385) v(n387) v(n194) v(n178) v(n187) v(n154) v(n395) v(n397) v(n138) v(n399) v(n401) v(n214) v(n200) v(n147) v(n197) v(n179) v(n411) v(n413) v(n198) v(n189) v(n176) v(n419) v(n140) v(n161) v(n129) v(n426) v(n428) v(n204) v(n195) v(n170) v(n434) v(n127) v(n130) v(n439) v(n441) v(n184) v(n151) v(n445) v(n447) v(n162) v(n449) v(n451) v(n219) v(n216) v(n174) v(n118) v(n459) v(n461) v(n126) v(n463) v(n465) v(n188) v(n208) v(n228) v(n166) v(n206) v(n128) v(n477) v(n479) v(n149) v(n481) v(n483) v(n201) v(n172) v(n487) v(n489) v(n153) v(n491) v(n493) v(n210) v(n495) v(n207) v(n186) v(n501) v(n134) v(n157) v(n163) v(n135) v(n229) v(n139) v(n513) v(n122) v(n220) v(n225) v(n177) v(n159) v(n165) v(n217) v(n191) v(n175) v(n532) v(n167) v(n160) v(n136) v(n539) v(n541) v(n144) v(n543) v(n545) v(n211) v(n152) v(n203) v(n202) v(n131) v(n121) v(n209) v(n141) v(n199) v(n193) v(n565) v(n133) v(n227) v(n223) v(n572) v(n222) v(n221) v(n577) v(n190) v(n180) v(n169) v(n137) v(n158) v(n588) v(n590) v(n205) v(n156) v(n132) v(n596) v(n598) v(n120) v(n600) v(n602) v(n196) v(n185) v(n606) v(n168) v(n143) v(n611) v(n613) v(n218) v(n615) v(n117) v(n119) v(n620) v(n622) v(n181) v(n155) v(n123) v(n192) v(n173) v(n632) v(n124) v(n145) v(n637) v(n125) v(n234) v(n235) v(n236) v(n237) v(n238) v(n239) v(n240) v(n241) v(n242) v(n243) v(n244) v(n245) v(n246) v(n247) v(n248) v(n249) v(n250) v(n251) v(n252) v(n253) v(n254) v(n255) v(n256) v(n257) v(n258) v(n259) v(n260) v(n261) v(n262) v(n263) v(n264) v(n265) v(n266) v(n267) v(n268) v(n269) v(n270) v(n271) v(n272) v(n273) v(n274) v(n275) v(n276) v(n277) v(n278) v(n279) v(n450) v(n422) v(n282) v(n283) v(n284) v(n285) v(n286) v(n287) v(n288) v(n289) v(n290) v(n291) v(n292) v(n293) v(n442) v(n295) v(n296) v(n297) v(n298) v(n299) v(n300) v(n301) v(n302) v(n303) v(n304) v(n305) v(n306) v(n307) v(n308) v(n309) v(n310) v(n311) v(n312) v(n313) v(n314) v(n315) v(n316) v(n317) v(n318) v(n319) v(n320) v(n321) v(n322) v(n323) v(n324) v(n325) v(n326) v(n327) v(n328) v(n329) v(n330) v(n331) v(n332) v(n333) v(n334) v(n335) v(n336) v(n454) v(n338) v(n339) v(n340) v(n341) v(n342) v(n343) v(n344) v(n345) v(n346) v(n347) v(n399) v(n349) v(n350)
.print tran all
* plot v(gin) v(n0) v(n232) v(n215) v(n231) v(n226) v(n230) v(n224) v(n213) v(n212) v(n146) v(n368) v(n370) v(n183) v(n150) v(n148) v(n182) v(n171) v(n380) v(n164) v(n142) v(n385) v(n387) v(n194) v(n178) v(n187) v(n154) v(n395) v(n397) v(n138) v(n399) v(n401) v(n214) v(n200) v(n147) v(n197) v(n179) v(n411) v(n413) v(n198) v(n189) v(n176) v(n419) v(n140) v(n161) v(n129) v(n426) v(n428) v(n204) v(n195) v(n170) v(n434) v(n127) v(n130) v(n439) v(n441) v(n184) v(n151) v(n445) v(n447) v(n162) v(n449) v(n451) v(n219) v(n216) v(n174) v(n118) v(n459) v(n461) v(n126) v(n463) v(n465) v(n188) v(n208) v(n228) v(n166) v(n206) v(n128) v(n477) v(n479) v(n149) v(n481) v(n483) v(n201) v(n172) v(n487) v(n489) v(n153) v(n491) v(n493) v(n210) v(n495) v(n207) v(n186) v(n501) v(n134) v(n157) v(n163) v(n135) v(n229) v(n139) v(n513) v(n122) v(n220) v(n225) v(n177) v(n159) v(n165) v(n217) v(n191) v(n175) v(n532) v(n167) v(n160) v(n136) v(n539) v(n541) v(n144) v(n543) v(n545) v(n211) v(n152) v(n203) v(n202) v(n131) v(n121) v(n209) v(n141) v(n199) v(n193) v(n565) v(n133) v(n227) v(n223) v(n572) v(n222) v(n221) v(n577) v(n190) v(n180) v(n169) v(n137) v(n158) v(n588) v(n590) v(n205) v(n156) v(n132) v(n596) v(n598) v(n120) v(n600) v(n602) v(n196) v(n185) v(n606) v(n168) v(n143) v(n611) v(n613) v(n218) v(n615) v(n117) v(n119) v(n620) v(n622) v(n181) v(n155) v(n123) v(n192) v(n173) v(n632) v(n124) v(n145) v(n637) v(n125) v(n234) v(n235) v(n236) v(n237) v(n238) v(n239) v(n240) v(n241) v(n242) v(n243) v(n244) v(n245) v(n246) v(n247) v(n248) v(n249) v(n250) v(n251) v(n252) v(n253) v(n254) v(n255) v(n256) v(n257) v(n258) v(n259) v(n260) v(n261) v(n262) v(n263) v(n264) v(n265) v(n266) v(n267) v(n268) v(n269) v(n270) v(n271) v(n272) v(n273) v(n274) v(n275) v(n276) v(n277) v(n278) v(n279) v(n450) v(n422) v(n282) v(n283) v(n284) v(n285) v(n286) v(n287) v(n288) v(n289) v(n290) v(n291) v(n292) v(n293) v(n442) v(n295) v(n296) v(n297) v(n298) v(n299) v(n300) v(n301) v(n302) v(n303) v(n304) v(n305) v(n306) v(n307) v(n308) v(n309) v(n310) v(n311) v(n312) v(n313) v(n314) v(n315) v(n316) v(n317) v(n318) v(n319) v(n320) v(n321) v(n322) v(n323) v(n324) v(n325) v(n326) v(n327) v(n328) v(n329) v(n330) v(n331) v(n332) v(n333) v(n334) v(n335) v(n336) v(n454) v(n338) v(n339) v(n340) v(n341) v(n342) v(n343) v(n344) v(n345) v(n346) v(n347) v(n399) v(n349) v(n350)
.end
