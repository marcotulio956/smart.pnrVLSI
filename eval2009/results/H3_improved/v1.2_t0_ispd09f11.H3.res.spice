* spice from ispd09f11.H3.res
.include /home/mark/smart.pnrVLSI/ispd09CNS_results/ispd09_benchmarks/tuned_45nm_HP.pm
.subckt inv0 in out vdd
m1  out in  vdd vdd   pmos l=45n w=14.6u
m2  out in  0   0     nmos l=45n w=10.0u
.ends inv0
.subckt inv1 in out vdd
m1  out in  vdd vdd   pmos l=45n w=2.0u
m2  out in  0   0     nmos l=45n w=1.37u
.ends inv1
c0 n0 0 0f
c1 n121 0 36.80985f
c2 n122 0 46.61695f
c3 n123 0 38.53245f
c4 n124 0 30.6333f
c5 n125 0 49.42725f
c6 n126 0 40.18055f
c7 n127 0 0f
c8 n128 0 42.327775f
c9 n129 0 34.96195f
c10 n130 0 43.86055f
c11 n131 0 34.01065f
c12 n132 0 26.1072f
c13 n133 0 48.6048f
c14 n134 0 7.0553875f
c15 n135 0 45.45225f
c16 n136 0 44.63405f
c17 n137 0 47.2998f
c18 n138 0 38.8665f
c19 n139 0 49.6867f
c20 n140 0 44.4929f
c21 n141 0 47.341f
c22 n142 0 26.379925f
c23 n143 0 27.7516f
c24 n144 0 47.3163f
c25 n145 0 15.5851f
c26 n146 0 25.5771f
c27 n147 0 28.33375f
c28 n148 0 42.923025f
c29 n149 0 26.98185f
c30 n150 0 0f
c31 n151 0 43.1231f
c32 n152 0 24.82935f
c33 n153 0 48.1924f
c34 n154 0 49.1665f
c35 n155 0 29.5281f
c36 n156 0 48.9676f
c37 n157 0 29.114f
c38 n158 0 40.37585f
c39 n159 0 21.3837f
c40 n160 0 46.93485f
c41 n161 0 33.6338f
c42 n162 0 33.9933375f
c43 n163 0 31.325f
c44 n164 0 29.9213f
c45 n165 0 46.75615f
c46 n166 0 35.9137f
c47 n167 0 48.02165f
c48 n168 0 39.23295f
c49 n169 0 30.87055f
c50 n170 0 33.15855f
c51 n171 0 39.32135f
c52 n172 0 30.83235f
c53 n173 0 29.6741f
c54 n174 0 26.48f
c55 n175 0 0f
c56 n176 0 32.66695f
c57 n177 0 0f
c58 n178 0 1.96625f
c59 n179 0 42.25285f
c60 n180 0 43.97305f
c61 n181 0 40.316775f
c62 n182 0 37.14765f
c63 n183 0 34.36255f
c64 n184 0 40.53425f
c65 n185 0 41.09775f
c66 n186 0 3.4881f
c67 n187 0 0f
c68 n188 0 36.74815f
c69 n189 0 35.0476f
c70 n190 0 0f
c71 n191 0 37.8666f
c72 n192 0 42.262f
c73 n193 0 42.025525f
c74 n194 0 41.310325f
c75 n195 0 0f
c76 n196 0 24.296475f
c77 n197 0 38.46495f
c78 n198 0 31.29905f
c79 n199 0 24.24685f
c80 n200 0 49.5366f
c81 n201 0 13.3803f
c82 n202 0 47.3242f
c83 n203 0 0f
c84 n204 0 43.77755f
c85 n205 0 30.9683f
c86 n206 0 27.8056f
c87 n207 0 39.06875f
c88 n208 0 44.02485f
c89 n209 0 37.562f
c90 n210 0 41.03695f
c91 n211 0 42.542975f
c92 n212 0 0f
c93 n213 0 41.6533f
c94 n214 0 44.436f
c95 n215 0 0f
c96 n216 0 41.9705375f
c97 n217 0 46.3223f
c98 n218 0 48.54135f
c99 n219 0 4.4834f
c100 n220 0 41.0145375f
c101 n221 0 0f
c102 n222 0 34.66895f
c103 n223 0 0f
c104 n224 0 48.73975f
c105 n225 0 44.4709f
c106 n226 0 43.14325f
c107 n227 0 45.641f
c108 n228 0 0f
c109 n229 0 0f
c110 n230 0 15.9602f
c111 n231 0 44.30355f
c112 n232 0 44.6727375f
c113 n233 0 43.9788f
c114 n234 0 48.54995f
c115 n235 0 0f
c116 n236 0 48.4931375f
c117 n237 0 44.3393625f
c118 n238 0 48.4454625f
c119 n239 0 0f
c120 n240 0 48.2105375f
c121 n363 0 48.2123f
c122 n365 0 41.0151f
c123 n366 0 42.328f
c124 n367 0 24.296475f
c125 n368 0 0f
c126 n369 0 11.61945f
c127 n371 0 48.6049f
c128 n372 0 47.3002f
c129 n373 0 0f
c130 n374 0 42.48295f
c131 n375 0 0f
c132 n376 0 42.48295f
c133 n377 0 0f
c134 n378 0 38.56855f
c135 n379 0 0f
c136 n380 0 38.56855f
c137 n381 0 0f
c138 n382 0 37.642f
c139 n383 0 0f
c140 n384 0 37.642f
c141 n385 0 33.9933375f
c142 n387 0 0f
c143 n388 0 34.1287f
c144 n390 0 48.4934f
c145 n391 0 48.4456f
c146 n392 0 15.9602f
c147 n394 0 46.61695f
c148 n396 0 44.4718f
c149 n397 0 45.6414f
c150 n398 0 40.3172f
c151 n399 0 43.14325f
c152 n400 0 41.098f
c153 n401 0 43.7778f
c154 n402 0 40.4907f
c155 n403 0 30.8707f
c156 n404 0 0f
c157 n405 0 29.8655f
c158 n406 0 0f
c159 n407 0 29.8654f
c160 n408 0 33.6339f
c161 n409 0 29.6741f
c162 n410 0 0f
c163 n411 0 35.0817f
c164 n412 0 34.96195f
c165 n413 0 35.20125f
c166 n414 0 35.20125f
c167 n415 0 0f
c168 n416 0 31.1219f
c169 n417 0 15.5851f
c170 n418 0 46.6586f
c171 n419 0 46.6586f
c172 n420 0 42.9231f
c173 n421 0 42.025525f
c174 n422 0 46.3273f
c175 n423 0 47.3163f
c176 n424 0 0f
c177 n425 0 45.3382f
c178 n426 0 0f
c179 n427 0 45.3382f
c180 n428 0 17.97225f
c181 n430 0 0f
c182 n431 0 39.8478f
c183 n432 0 0f
c184 n433 0 39.8478f
c185 n434 0 48.5415f
c186 n435 0 34.6693f
c187 n436 0 31.2992f
c188 n437 0 46.3223f
c189 n438 0 42.2529f
c190 n439 0 40.1808f
c191 n440 0 0f
c192 n441 0 35.6033f
c193 n442 0 0f
c194 n443 0 35.6033f
c195 n444 0 0f
c196 n445 0 35.8199f
c197 n446 0 24.82935f
c198 n447 0 46.81035f
c199 n448 0 46.81035f
c200 n449 0 36.7483f
c201 n450 0 40.5344f
c202 n451 0 0f
c203 n452 0 29.4005f
c204 n453 0 0f
c205 n454 0 29.4005f
c206 n455 0 0f
c207 n456 0 33.1866f
c208 n457 0 0f
c209 n458 0 33.1866f
c210 n459 0 0f
c211 n460 0 40.2128f
c212 n461 0 24.24685f
c213 n462 0 30.8326f
c214 n463 0 39.3215f
c215 n464 0 0f
c216 n465 0 28.9807f
c217 n466 0 0f
c218 n467 0 28.9807f
c219 n468 0 0f
c220 n469 0 37.4697f
c221 n470 0 26.98185f
c222 n471 0 47.9573f
c223 n472 0 47.9573f
c224 n473 0 0f
c225 n474 0 33.91435f
c226 n475 0 0f
c227 n476 0 33.91435f
c228 n477 0 37.5622f
c229 n478 0 41.0371f
c230 n479 0 44.436f
c231 n480 0 27.8057f
c232 n481 0 44.4931f
c233 n482 0 46.93485f
c234 n483 0 45.45225f
c235 n484 0 44.63405f
c236 n485 0 41.69295f
c237 n486 0 41.69295f
c238 n487 0 40.87475f
c239 n488 0 40.87475f
c240 n489 0 0f
c241 n490 0 44.27585f
c242 n491 0 0f
c243 n492 0 44.27585f
c244 n493 0 48.9676f
c245 n494 0 33.3338f
c246 n495 0 0f
c247 n496 0 25.5168f
c248 n497 0 0f
c249 n498 0 25.5168f
c250 n499 0 49.5368f
c251 n500 0 44.0251f
c252 n501 0 36.0867f
c253 n502 0 35.0476f
c254 n503 0 0f
c255 n504 0 36.6063f
c256 n505 0 27.7516f
c257 n506 0 45.46075f
c258 n507 0 45.46075f
c259 n508 0 34.0108f
c260 n509 0 32.667f
c261 n510 0 0f
c262 n511 0 37.9639f
c263 n512 0 21.3837f
c264 n513 0 27.2721f
c265 n514 0 27.272f
c266 n515 0 0f
c267 n516 0 39.22935f
c268 n517 0 0f
c269 n518 0 39.22935f
c270 n519 0 44.3405f
c271 n520 0 48.5505f
c272 n521 0 39.0689f
c273 n523 0 42.2625f
c274 n524 0 43.9788f
c275 n526 0 38.5326f
c276 n527 0 0f
c277 n528 0 31.5069f
c278 n529 0 0f
c279 n530 0 31.5069f
c280 n531 0 0f
c281 n532 0 41.47015f
c282 n535 0 34.69765f
c283 n536 0 48.7401f
c284 n537 0 47.3247f
c285 n538 0 37.3841f
c286 n539 0 31.325f
c287 n540 0 0f
c288 n541 0 49.50195f
c289 n542 0 0f
c290 n543 0 49.50195f
c291 n544 0 38.8076f
c292 n545 0 4.4834f
c293 n546 0 37.8666f
c294 n547 0 48.0218f
c295 n548 0 27.3518f
c296 n549 0 27.3518f
c297 n550 0 37.5069f
c298 n551 0 28.33375f
c299 n552 0 0f
c300 n553 0 46.67995f
c301 n554 0 0f
c302 n555 0 46.67995f
c303 n556 0 49.4274f
c304 n557 0 26.48f
c305 n558 0 29.5281f
c306 n559 0 46.75615f
c307 n560 0 30.5787f
c308 n561 0 30.5787f
c309 n562 0 48.85725f
c310 n563 0 48.85725f
c311 n564 0 0f
c312 n565 0 35.5388f
c313 n566 0 0f
c314 n567 0 35.5388f
c315 n568 0 38.8666f
c316 n570 0 39.2331f
c317 n571 0 35.9139f
c318 n572 0 0f
c319 n573 0 32.9835f
c320 n574 0 36.80985f
c321 n575 0 29.15685f
c322 n576 0 29.15685f
c323 n577 0 0f
c324 n578 0 29.6642f
c325 n579 0 0f
c326 n580 0 29.6642f
c327 n581 0 42.4631f
c328 n582 0 42.4631f
c329 n583 0 7.0553875f
c330 n585 0 41.9709f
c331 n586 0 44.6728f
c332 n587 0 26.38f
c333 n589 0 42.5431f
c334 n590 0 41.3105f
c335 n592 0 3.4881f
c336 n593 0 0f
c337 n594 0 32.6427f
c338 n595 0 0f
c339 n596 0 32.6427f
c340 n597 0 37.1478f
c341 n598 0 48.1927f
c342 n599 0 47.3717f
c343 n600 0 47.3717f
c344 n601 0 40.2532f
c345 n602 0 29.114f
c346 n603 0 0f
c347 n604 0 25.6962f
c348 n605 0 0f
c349 n606 0 25.6962f
c350 n607 0 33.15855f
c351 n608 0 43.8606f
c352 n609 0 0f
c353 n610 0 37.70985f
c354 n611 0 0f
c355 n612 0 37.70985f
c356 n613 0 30.6334f
c357 n614 0 49.6867f
c358 n615 0 42.58575f
c359 n616 0 42.58575f
c360 n617 0 31.00575f
c361 n618 0 31.00575f
c362 n619 0 0f
c363 n620 0 42.66875f
c364 n621 0 0f
c365 n622 0 42.66875f
c366 n623 0 5.129f
c367 n625 0 44.3036f
c368 n626 0 41.6541f
c369 n627 0 40.3759f
c370 n628 0 34.3628f
c371 n629 0 0f
c372 n630 0 34.2017f
c373 n631 0 1.96625f
c374 n632 0 33.2186f
c375 n633 0 33.2186f
c376 n634 0 47.341f
c377 n635 0 43.1231f
c378 n636 0 47.61665f
c379 n637 0 47.61665f
c380 n638 0 43.39875f
c381 n639 0 43.39875f
c382 n640 0 43.9732f
c383 n641 0 38.4653f
c384 n642 0 0f
c385 n643 0 46.4948f
c386 n644 0 26.1072f
c387 n645 0 40.7752f
c388 n646 0 40.7752f
c389 n647 0 30.9683f
c390 n648 0 29.9213f
c391 n649 0 49.5309f
c392 n650 0 49.1665f
c393 n651 0 0f
c394 n652 0 49.8951f
c395 n653 0 0f
c396 n654 0 49.8951f
c397 n655 0 25.5772f
c398 n656 0 13.3803f
c399 n657 0 0f
c400 n658 0 41.7937f
c401 n659 0 0f
c402 n660 0 41.7937f
c403 n661 0 0f
c404 n662 0 45.8133f
c405 n663 0 0f
c406 n664 0 45.8133f
c407 n665 0 0f
c408 n666 0 38.13745f
c409 n667 0 0f
c410 n668 0 38.13745f
c411 n669 0 0f
c412 n670 0 27.462f
c413 n671 0 0f
c414 n672 0 27.462f
c415 n242 0 82.61665f
c416 n243 0 82.61665f
c417 n244 0 68.2185f
c418 n245 0 69.20165f
c419 n246 0 81.4948f
c420 n247 0 75.7752f
c421 n248 0 75.7752f
c422 n249 0 73.8075f
c423 n250 0 66.5069f
c424 n251 0 66.5069f
c425 n252 0 72.38375f
c426 n253 0 78.39875f
c427 n254 0 78.39875f
c428 n255 0 68.2185f
c429 n256 0 40.129f
c430 n257 0 84.8951f
c431 n258 0 76.7936f
c432 n259 0 62.35165f
c433 n260 0 62.35165f
c434 n261 0 69.69765f
c435 n262 0 76.47015f
c436 n263 0 84.50195f
c437 n264 0 77.58575f
c438 n265 0 66.00575f
c439 n266 0 77.66875f
c440 n267 0 73.13745f
c441 n268 0 84.8951f
c442 n269 0 80.8133f
c443 n270 0 76.7936f
c444 n271 0 81.67995f
c445 n272 0 72.5068f
c446 n273 0 77.4631f
c447 n274 0 84.50195f
c448 n275 0 77.58575f
c449 n276 0 66.00575f
c450 n277 0 77.66875f
c451 n278 0 73.13745f
c452 n279 0 84.5307f
c453 n280 0 80.8133f
c454 n281 0 77.48295f
c455 n282 0 81.67995f
c456 n283 0 67.9832f
c457 n284 0 77.4631f
c458 n285 0 64.66405f
c459 n286 0 72.70985f
c460 n287 0 72.70985f
c461 n288 0 67.6426f
c462 n289 0 75.25305f
c463 n290 0 62.4619f
c464 n291 0 62.4619f
c465 n292 0 77.48295f
c466 n293 0 72.642f
c467 n294 0 64.15685f
c468 n295 0 64.15685f
c469 n296 0 64.66405f
c470 n297 0 82.3717f
c471 n298 0 82.3717f
c472 n299 0 67.6426f
c473 n300 0 60.69605f
c474 n301 0 60.69605f
c475 n302 0 69.1285625f
c476 n303 0 46.61945f
c477 n304 0 72.642f
c478 n305 0 83.85725f
c479 n306 0 83.85725f
c480 n307 0 70.5388f
c481 n308 0 75.21255f
c482 n309 0 82.9573f
c483 n310 0 63.98055f
c484 n311 0 76.69295f
c485 n312 0 75.87475f
c486 n313 0 68.33355f
c487 n314 0 73.56855f
c488 n315 0 73.56855f
c489 n316 0 65.5786f
c490 n317 0 65.5786f
c491 n318 0 70.5388f
c492 n319 0 72.46945f
c493 n320 0 82.9573f
c494 n321 0 63.98055f
c495 n322 0 76.69295f
c496 n323 0 75.87475f
c497 n324 0 60.51675f
c498 n325 0 60.51675f
c499 n326 0 70.0815f
c500 n327 0 66.1218f
c501 n328 0 81.6586f
c502 n329 0 75.4906f
c503 n330 0 68.18645f
c504 n331 0 68.18645f
c505 n332 0 70.6033f
c506 n333 0 79.27585f
c507 n334 0 79.27585f
c508 n335 0 68.91435f
c509 n336 0 71.60605f
c510 n337 0 70.20125f
c511 n338 0 70.20125f
c512 n339 0 81.6586f
c513 n340 0 64.86525f
c514 n341 0 64.40035f
c515 n342 0 70.8198f
c516 n343 0 70.6033f
c517 n344 0 74.22935f
c518 n345 0 72.96375f
c519 n346 0 68.91435f
c520 n347 0 80.46075f
c521 n348 0 80.46075f
c522 n349 0 74.84775f
c523 n350 0 81.3272f
c524 n351 0 64.86535f
c525 n352 0 64.40035f
c526 n353 0 81.81035f
c527 n354 0 81.81035f
c528 n355 0 74.22935f
c529 n356 0 62.27185f
c530 n357 0 62.27195f
c531 n358 0 71.08655f
c532 n359 0 74.84775f
c533 n360 0 52.97225f
c534 n361 0 80.3382f
c535 n362 0 80.3382f
c536 nSEG_NODE_552 0 96.4246f
c537 nSEG_NODE_553 0 96.4246f
c538 nSEG_NODE_554 0 96.4246f
c539 nSEG_NODE_555 0 96.4246f
c540 nSEG_NODE_556 0 96.4246f
c541 nSEG_NODE_557 0 96.4246f
c542 nSEG_NODE_558 0 96.4246f
c543 nSEG_NODE_559 0 96.4246f
c544 nSEG_NODE_560 0 96.4246f
c545 nSEG_NODE_561 0 96.4246f
c546 nSEG_NODE_562 0 96.4246f
c547 nSEG_NODE_563 0 96.4246f
c548 nSEG_NODE_564 0 96.4246f
c549 nSEG_NODE_565 0 96.4246f
c550 nSEG_NODE_566 0 96.4246f
c551 nSEG_NODE_567 0 96.4246f
c552 nSEG_NODE_568 0 96.4246f
c553 nSEG_NODE_569 0 96.4246f
c554 nSEG_NODE_570 0 96.4246f
c555 nSEG_NODE_571 0 96.4228375f
c556 nSEG_NODE_572 0 82.0302f
c557 nSEG_NODE_573 0 82.0302f
c558 nSEG_NODE_574 0 82.0296375f
c559 nSEG_NODE_575 0 84.655775f
c560 nSEG_NODE_576 0 97.2098f
c561 nSEG_NODE_577 0 97.2097f
c562 nSEG_NODE_578 0 94.6004f
c563 nSEG_NODE_579 0 94.6f
c564 nSEG_NODE_580 0 68.2572625f
c565 nSEG_NODE_581 0 96.9868f
c566 nSEG_NODE_582 0 96.9865375f
c567 nSEG_NODE_583 0 96.8912f
c568 nSEG_NODE_584 0 96.8912f
c569 nSEG_NODE_585 0 96.8912f
c570 nSEG_NODE_586 0 96.8912f
c571 nSEG_NODE_587 0 96.8912f
c572 nSEG_NODE_588 0 96.8912f
c573 nSEG_NODE_589 0 96.8910625f
c574 nSEG_NODE_590 0 88.9436f
c575 nSEG_NODE_591 0 88.9436f
c576 nSEG_NODE_592 0 88.9436f
c577 nSEG_NODE_593 0 88.9436f
c578 nSEG_NODE_594 0 88.9436f
c579 nSEG_NODE_595 0 88.9436f
c580 nSEG_NODE_596 0 88.9436f
c581 nSEG_NODE_597 0 88.9427f
c582 nSEG_NODE_598 0 91.2828f
c583 nSEG_NODE_599 0 91.2828f
c584 nSEG_NODE_600 0 91.2828f
c585 nSEG_NODE_601 0 91.2828f
c586 nSEG_NODE_602 0 91.2828f
c587 nSEG_NODE_603 0 91.2828f
c588 nSEG_NODE_604 0 91.2828f
c589 nSEG_NODE_605 0 91.2824f
c590 nSEG_NODE_606 0 80.6344f
c591 nSEG_NODE_607 0 80.6344f
c592 nSEG_NODE_608 0 80.633975f
c593 nSEG_NODE_609 0 82.196f
c594 nSEG_NODE_610 0 82.19575f
c595 nSEG_NODE_611 0 87.5556f
c596 nSEG_NODE_612 0 87.55535f
c597 nSEG_NODE_613 0 80.9814f
c598 nSEG_NODE_614 0 80.9813f
c599 nSEG_NODE_615 0 61.74125f
c600 nSEG_NODE_616 0 59.73075f
c601 nSEG_NODE_617 0 59.73075f
c602 nSEG_NODE_618 0 67.2677f
c603 nSEG_NODE_619 0 59.3482f
c604 nSEG_NODE_620 0 70.1632f
c605 nSEG_NODE_621 0 62.2437f
c606 nSEG_NODE_622 0 85.846125f
c607 nSEG_NODE_623 0 92.6545f
c608 nSEG_NODE_624 0 79.69555f
c609 nSEG_NODE_625 0 79.69555f
c610 nSEG_NODE_626 0 97.083f
c611 nSEG_NODE_627 0 97.08285f
c612 nSEG_NODE_628 0 69.3386f
c613 nSEG_NODE_629 0 69.33825f
c614 nSEG_NODE_630 0 62.59825f
c615 nSEG_NODE_631 0 84.50575f
c616 nSEG_NODE_632 0 80.3616f
c617 nSEG_NODE_633 0 80.36135f
c618 nSEG_NODE_634 0 71.6397f
c619 nSEG_NODE_635 0 73.49645f
c620 nSEG_NODE_636 0 81.06865f
c621 nSEG_NODE_637 0 58.80085f
c622 nSEG_NODE_638 0 58.80085f
c623 nSEG_NODE_639 0 66.37305f
c624 nSEG_NODE_640 0 66.37305f
c625 nSEG_NODE_641 0 80.4256f
c626 nSEG_NODE_642 0 80.4256f
c627 nSEG_NODE_643 0 80.42535f
c628 nSEG_NODE_644 0 61.66495f
c629 nSEG_NODE_645 0 78.64285f
c630 nSEG_NODE_646 0 57.96125f
c631 nSEG_NODE_647 0 57.96125f
c632 nSEG_NODE_648 0 74.93915f
c633 nSEG_NODE_649 0 75.1244f
c634 nSEG_NODE_650 0 75.1242f
c635 nSEG_NODE_651 0 82.0742f
c636 nSEG_NODE_652 0 82.0742f
c637 nSEG_NODE_653 0 82.07405f
c638 nSEG_NODE_654 0 88.872f
c639 nSEG_NODE_655 0 55.6113f
c640 nSEG_NODE_656 0 88.986f
c641 nSEG_NODE_657 0 66.6676f
c642 nSEG_NODE_658 0 66.66735f
c643 nSEG_NODE_659 0 51.03355f
c644 nSEG_NODE_660 0 51.03355f
c645 nSEG_NODE_661 0 99.0734f
c646 nSEG_NODE_662 0 88.0502f
c647 nSEG_NODE_663 0 88.04995f
c648 nSEG_NODE_664 0 72.1734f
c649 nSEG_NODE_665 0 72.17325f
c650 nSEG_NODE_666 0 73.21235f
c651 nSEG_NODE_667 0 68.0216f
c652 nSEG_NODE_668 0 68.02145f
c653 nSEG_NODE_669 0 65.33395f
c654 nSEG_NODE_670 0 75.92765f
c655 nSEG_NODE_671 0 54.54395f
c656 nSEG_NODE_672 0 54.54395f
c657 nSEG_NODE_673 0 88.681f
c658 nSEG_NODE_674 0 88.681f
c659 nSEG_NODE_675 0 88.681f
c660 nSEG_NODE_676 0 88.681f
c661 nSEG_NODE_677 0 88.681f
c662 nSEG_NODE_678 0 88.681f
c663 nSEG_NODE_679 0 88.6798625f
c664 nSEG_NODE_680 0 97.101f
c665 nSEG_NODE_681 0 97.101f
c666 nSEG_NODE_682 0 97.101f
c667 nSEG_NODE_683 0 97.101f
c668 nSEG_NODE_684 0 97.10045f
c669 nSEG_NODE_685 0 78.13765f
c670 nSEG_NODE_686 0 84.525f
c671 nSEG_NODE_687 0 84.525f
c672 nSEG_NODE_688 0 84.525f
c673 nSEG_NODE_689 0 84.525f
c674 nSEG_NODE_690 0 84.5245f
c675 nSEG_NODE_691 0 87.9576f
c676 nSEG_NODE_692 0 87.9576f
c677 nSEG_NODE_693 0 87.9576f
c678 nSEG_NODE_694 0 87.9576f
c679 nSEG_NODE_695 0 77.0652f
c680 nSEG_NODE_696 0 77.06505f
c681 nSEG_NODE_697 0 97.4802f
c682 nSEG_NODE_698 0 97.47985f
c683 nSEG_NODE_699 0 94.6494f
c684 nSEG_NODE_700 0 94.6494f
c685 nSEG_NODE_701 0 94.6489f
c686 nSEG_NODE_702 0 74.7682f
c687 nSEG_NODE_703 0 74.76785f
c688 nSEG_NODE_704 0 62.65f
c689 nSEG_NODE_705 0 77.6152f
c690 nSEG_NODE_706 0 77.6152f
c691 nSEG_NODE_707 0 77.6151f
c692 nSEG_NODE_708 0 75.7332f
c693 nSEG_NODE_709 0 96.04345f
c694 nSEG_NODE_710 0 54.70345f
c695 nSEG_NODE_711 0 54.70345f
c696 nSEG_NODE_712 0 75.0137f
c697 nSEG_NODE_713 0 98.85465f
c698 nSEG_NODE_714 0 59.0562f
c699 nSEG_NODE_715 0 61.1573f
c700 nSEG_NODE_716 0 61.1573f
c701 nSEG_NODE_717 0 77.7331f
c702 nSEG_NODE_718 0 78.46605f
c703 nSEG_NODE_719 0 71.8276f
c704 nSEG_NODE_720 0 65.9667f
c705 nSEG_NODE_721 0 59.32825f
c706 nSEG_NODE_722 0 59.32825f
c707 nSEG_NODE_723 0 83.9418f
c708 nSEG_NODE_724 0 83.9418f
c709 nSEG_NODE_725 0 83.9414375f
c710 nSEG_NODE_726 0 89.3456f
c711 nSEG_NODE_727 0 89.3455375f
c712 nSEG_NODE_728 0 52.759925f
c713 nSEG_NODE_729 0 85.0862f
c714 nSEG_NODE_730 0 85.0862f
c715 nSEG_NODE_731 0 85.086075f
c716 nSEG_NODE_732 0 82.621f
c717 nSEG_NODE_733 0 82.621f
c718 nSEG_NODE_734 0 82.620825f
c719 nSEG_NODE_735 0 65.2853f
c720 nSEG_NODE_736 0 65.2853f
c721 nSEG_NODE_737 0 74.2956f
c722 nSEG_NODE_738 0 74.29545f
c723 nSEG_NODE_739 0 96.3854f
c724 nSEG_NODE_740 0 96.3851f
c725 nSEG_NODE_741 0 80.50625f
c726 nSEG_NODE_742 0 51.39225f
c727 nSEG_NODE_743 0 51.39225f
c728 nSEG_NODE_744 0 87.72115f
c729 nSEG_NODE_745 0 61.2667f
c730 nSEG_NODE_746 0 88.6072f
c731 nSEG_NODE_747 0 88.60715f
c732 nSEG_NODE_748 0 83.3082f
c733 nSEG_NODE_749 0 83.3082f
c734 nSEG_NODE_750 0 83.3082f
c735 nSEG_NODE_751 0 83.3074f
c736 nSEG_NODE_752 0 80.75175f
c737 nSEG_NODE_753 0 68.7256f
c738 nSEG_NODE_754 0 68.72535f
c739 nSEG_NODE_755 0 68.40335f
c740 nSEG_NODE_756 0 66.4371f
c741 nSEG_NODE_757 0 66.4371f
c742 nSEG_NODE_758 0 87.94625f
c743 nSEG_NODE_759 0 76.9306f
c744 nSEG_NODE_760 0 76.9306f
c745 nSEG_NODE_761 0 76.93025f
c746 nSEG_NODE_762 0 92.9896f
c747 nSEG_NODE_763 0 52.2144f
c748 nSEG_NODE_764 0 61.9366f
c749 nSEG_NODE_765 0 59.8426f
c750 nSEG_NODE_766 0 99.0616f
c751 nSEG_NODE_767 0 51.1543f
c752 nSEG_NODE_768 0 83.5873f
c753 nSEG_NODE_769 0 83.5873f
c754 nSEG_NODE_770 0 54.9239f
c755 nSEG_NODE_771 0 54.9239f
r0 n367 n196 24.296475
r1 n369 n303 11.61945
r2 n374 n281 42.48295
r3 n376 n292 42.48295
r4 n378 n314 38.56855
r5 n380 n315 38.56855
r6 n382 n293 37.642
r7 n384 n304 37.642
r8 n385 n162 33.9933375
r9 n392 n230 15.9602
r10 n394 n122 46.61695
r11 n399 n226 43.14325
r12 n412 n129 34.96195
r13 n413 n337 35.20125
r14 n414 n338 35.20125
r15 n417 n145 15.5851
r16 n418 n328 46.6586
r17 n419 n339 46.6586
r18 n421 n193 42.025525
r19 n423 n144 47.3163
r20 n425 n361 45.3382
r21 n427 n362 45.3382
r22 n428 n360 17.97225
r23 n437 n217 46.3223
r24 n441 n332 35.6033
r25 n443 n343 35.6033
r26 n446 n152 24.82935
r27 n447 n353 46.81035
r28 n448 n354 46.81035
r29 n461 n199 24.24685
r30 n470 n149 26.98185
r31 n471 n309 47.9573
r32 n472 n320 47.9573
r33 n474 n335 33.91435
r34 n476 n346 33.91435
r35 n482 n160 46.93485
r36 n483 n135 45.45225
r37 n484 n136 44.63405
r38 n485 n311 41.69295
r39 n486 n322 41.69295
r40 n487 n312 40.87475
r41 n488 n323 40.87475
r42 n490 n333 44.27585
r43 n492 n334 44.27585
r44 n493 n156 48.9676
r45 n502 n189 35.0476
r46 n505 n143 27.7516
r47 n506 n347 45.46075
r48 n507 n348 45.46075
r49 n512 n159 21.3837
r50 n516 n344 39.22935
r51 n518 n355 39.22935
r52 n528 n250 31.5069
r53 n530 n251 31.5069
r54 n532 n262 41.47015
r55 n535 n261 34.69765
r56 n541 n263 49.50195
r57 n543 n274 49.50195
r58 n545 n219 4.4834
r59 n551 n147 28.33375
r60 n553 n271 46.67995
r61 n555 n282 46.67995
r62 n557 n174 26.48
r63 n559 n165 46.75615
r64 n562 n305 48.85725
r65 n563 n306 48.85725
r66 n565 n307 35.5388
r67 n567 n318 35.5388
r68 n574 n121 36.80985
r69 n575 n294 29.15685
r70 n576 n295 29.15685
r71 n581 n273 42.4631
r72 n582 n284 42.4631
r73 n583 n134 7.0553875
r74 n592 n186 3.4881
r75 n599 n297 47.3717
r76 n600 n298 47.3717
r77 n602 n157 29.114
r78 n607 n170 33.15855
r79 n610 n286 37.70985
r80 n612 n287 37.70985
r81 n614 n139 49.6867
r82 n615 n264 42.58575
r83 n616 n275 42.58575
r84 n617 n265 31.00575
r85 n618 n276 31.00575
r86 n620 n266 42.66875
r87 n622 n277 42.66875
r88 n623 n256 5.129
r89 n631 n178 1.96625
r90 n634 n141 47.341
r91 n635 n151 43.1231
r92 n636 n242 47.61665
r93 n637 n243 47.61665
r94 n638 n253 43.39875
r95 n639 n254 43.39875
r96 n645 n247 40.7752
r97 n646 n248 40.7752
r98 n650 n154 49.1665
r99 n652 n257 49.8951
r100 n654 n268 49.8951
r101 n656 n201 13.3803
r102 n662 n269 45.8133
r103 n664 n280 45.8133
r104 n666 n267 38.13745
r105 n668 n278 38.13745
r106 n363 nSEG_NODE_552 48.2123
r107 nSEG_NODE_552 nSEG_NODE_553 48.2123
r108 nSEG_NODE_553 nSEG_NODE_554 48.2123
r109 nSEG_NODE_554 nSEG_NODE_555 48.2123
r110 nSEG_NODE_555 nSEG_NODE_556 48.2123
r111 nSEG_NODE_556 nSEG_NODE_557 48.2123
r112 nSEG_NODE_557 nSEG_NODE_558 48.2123
r113 nSEG_NODE_558 nSEG_NODE_559 48.2123
r114 nSEG_NODE_559 nSEG_NODE_560 48.2123
r115 nSEG_NODE_560 nSEG_NODE_561 48.2123
r116 nSEG_NODE_561 nSEG_NODE_562 48.2123
r117 nSEG_NODE_562 nSEG_NODE_563 48.2123
r118 nSEG_NODE_563 nSEG_NODE_564 48.2123
r119 nSEG_NODE_564 nSEG_NODE_565 48.2123
r120 nSEG_NODE_565 nSEG_NODE_566 48.2123
r121 nSEG_NODE_566 nSEG_NODE_567 48.2123
r122 nSEG_NODE_567 nSEG_NODE_568 48.2123
r123 nSEG_NODE_568 nSEG_NODE_569 48.2123
r124 nSEG_NODE_569 nSEG_NODE_570 48.2123
r125 nSEG_NODE_570 nSEG_NODE_571 48.2123
r126 nSEG_NODE_571 n240 48.2105375
r127 n365 nSEG_NODE_572 41.0151
r128 nSEG_NODE_572 nSEG_NODE_573 41.0151
r129 nSEG_NODE_573 nSEG_NODE_574 41.0151
r130 nSEG_NODE_574 n220 41.0145375
r131 n366 nSEG_NODE_575 42.328
r132 nSEG_NODE_575 n128 42.327775
r133 n371 nSEG_NODE_576 48.6049
r134 nSEG_NODE_576 nSEG_NODE_577 48.6049
r135 nSEG_NODE_577 n133 48.6048
r136 n372 nSEG_NODE_578 47.3002
r137 nSEG_NODE_578 nSEG_NODE_579 47.3002
r138 nSEG_NODE_579 n137 47.2998
r139 n388 nSEG_NODE_580 34.1287
r140 nSEG_NODE_580 n302 34.1285625
r141 n390 nSEG_NODE_581 48.4934
r142 nSEG_NODE_581 nSEG_NODE_582 48.4934
r143 nSEG_NODE_582 n236 48.4931375
r144 n391 nSEG_NODE_583 48.4456
r145 nSEG_NODE_583 nSEG_NODE_584 48.4456
r146 nSEG_NODE_584 nSEG_NODE_585 48.4456
r147 nSEG_NODE_585 nSEG_NODE_586 48.4456
r148 nSEG_NODE_586 nSEG_NODE_587 48.4456
r149 nSEG_NODE_587 nSEG_NODE_588 48.4456
r150 nSEG_NODE_588 nSEG_NODE_589 48.4456
r151 nSEG_NODE_589 n238 48.4454625
r152 n396 nSEG_NODE_590 44.4718
r153 nSEG_NODE_590 nSEG_NODE_591 44.4718
r154 nSEG_NODE_591 nSEG_NODE_592 44.4718
r155 nSEG_NODE_592 nSEG_NODE_593 44.4718
r156 nSEG_NODE_593 nSEG_NODE_594 44.4718
r157 nSEG_NODE_594 nSEG_NODE_595 44.4718
r158 nSEG_NODE_595 nSEG_NODE_596 44.4718
r159 nSEG_NODE_596 nSEG_NODE_597 44.4718
r160 nSEG_NODE_597 n225 44.4709
r161 n397 nSEG_NODE_598 45.6414
r162 nSEG_NODE_598 nSEG_NODE_599 45.6414
r163 nSEG_NODE_599 nSEG_NODE_600 45.6414
r164 nSEG_NODE_600 nSEG_NODE_601 45.6414
r165 nSEG_NODE_601 nSEG_NODE_602 45.6414
r166 nSEG_NODE_602 nSEG_NODE_603 45.6414
r167 nSEG_NODE_603 nSEG_NODE_604 45.6414
r168 nSEG_NODE_604 nSEG_NODE_605 45.6414
r169 nSEG_NODE_605 n227 45.641
r170 n398 nSEG_NODE_606 40.3172
r171 nSEG_NODE_606 nSEG_NODE_607 40.3172
r172 nSEG_NODE_607 nSEG_NODE_608 40.3172
r173 nSEG_NODE_608 n181 40.316775
r174 n400 nSEG_NODE_609 41.098
r175 nSEG_NODE_609 nSEG_NODE_610 41.098
r176 nSEG_NODE_610 n185 41.09775
r177 n401 nSEG_NODE_611 43.7778
r178 nSEG_NODE_611 nSEG_NODE_612 43.7778
r179 nSEG_NODE_612 n204 43.77755
r180 n402 nSEG_NODE_613 40.4907
r181 nSEG_NODE_613 nSEG_NODE_614 40.4907
r182 nSEG_NODE_614 n329 40.4906
r183 n403 nSEG_NODE_615 30.8707
r184 nSEG_NODE_615 n169 30.87055
r185 n405 nSEG_NODE_616 29.8655
r186 nSEG_NODE_616 n340 29.86525
r187 n407 nSEG_NODE_617 29.8654
r188 nSEG_NODE_617 n351 29.86535
r189 n408 nSEG_NODE_618 33.6339
r190 nSEG_NODE_618 n161 33.6338
r191 n409 nSEG_NODE_619 29.6741
r192 nSEG_NODE_619 n173 29.6741
r193 n411 nSEG_NODE_620 35.0817
r194 nSEG_NODE_620 n326 35.0815
r195 n416 nSEG_NODE_621 31.1219
r196 nSEG_NODE_621 n327 31.1218
r197 n420 nSEG_NODE_622 42.9231
r198 nSEG_NODE_622 n148 42.923025
r199 n422 nSEG_NODE_623 46.3273
r200 nSEG_NODE_623 n350 46.3272
r201 n431 nSEG_NODE_624 39.8478
r202 nSEG_NODE_624 n359 39.84775
r203 n433 nSEG_NODE_625 39.8478
r204 nSEG_NODE_625 n349 39.84775
r205 n434 nSEG_NODE_626 48.5415
r206 nSEG_NODE_626 nSEG_NODE_627 48.5415
r207 nSEG_NODE_627 n218 48.54135
r208 n435 nSEG_NODE_628 34.6693
r209 nSEG_NODE_628 nSEG_NODE_629 34.6693
r210 nSEG_NODE_629 n222 34.66895
r211 n436 nSEG_NODE_630 31.2992
r212 nSEG_NODE_630 n198 31.29905
r213 n438 nSEG_NODE_631 42.2529
r214 nSEG_NODE_631 n179 42.25285
r215 n439 nSEG_NODE_632 40.1808
r216 nSEG_NODE_632 nSEG_NODE_633 40.1808
r217 nSEG_NODE_633 n126 40.18055
r218 n445 nSEG_NODE_634 35.8199
r219 nSEG_NODE_634 n342 35.8198
r220 n449 nSEG_NODE_635 36.7483
r221 nSEG_NODE_635 n188 36.74815
r222 n450 nSEG_NODE_636 40.5344
r223 nSEG_NODE_636 n184 40.53425
r224 n452 nSEG_NODE_637 29.4005
r225 nSEG_NODE_637 n341 29.40035
r226 n454 nSEG_NODE_638 29.4005
r227 nSEG_NODE_638 n352 29.40035
r228 n456 nSEG_NODE_639 33.1866
r229 nSEG_NODE_639 n330 33.18645
r230 n458 nSEG_NODE_640 33.1866
r231 nSEG_NODE_640 n331 33.18645
r232 n460 nSEG_NODE_641 40.2128
r233 nSEG_NODE_641 nSEG_NODE_642 40.2128
r234 nSEG_NODE_642 nSEG_NODE_643 40.2128
r235 nSEG_NODE_643 n308 40.21255
r236 n462 nSEG_NODE_644 30.8326
r237 nSEG_NODE_644 n172 30.83235
r238 n463 nSEG_NODE_645 39.3215
r239 nSEG_NODE_645 n171 39.32135
r240 n465 nSEG_NODE_646 28.9807
r241 nSEG_NODE_646 n310 28.98055
r242 n467 nSEG_NODE_647 28.9807
r243 nSEG_NODE_647 n321 28.98055
r244 n469 nSEG_NODE_648 37.4697
r245 nSEG_NODE_648 n319 37.46945
r246 n477 nSEG_NODE_649 37.5622
r247 nSEG_NODE_649 nSEG_NODE_650 37.5622
r248 nSEG_NODE_650 n209 37.562
r249 n478 nSEG_NODE_651 41.0371
r250 nSEG_NODE_651 nSEG_NODE_652 41.0371
r251 nSEG_NODE_652 nSEG_NODE_653 41.0371
r252 nSEG_NODE_653 n210 41.03695
r253 n479 nSEG_NODE_654 44.436
r254 nSEG_NODE_654 n214 44.436
r255 n480 nSEG_NODE_655 27.8057
r256 nSEG_NODE_655 n206 27.8056
r257 n481 nSEG_NODE_656 44.4931
r258 nSEG_NODE_656 n140 44.4929
r259 n494 nSEG_NODE_657 33.3338
r260 nSEG_NODE_657 nSEG_NODE_658 33.3338
r261 nSEG_NODE_658 n313 33.33355
r262 n496 nSEG_NODE_659 25.5168
r263 nSEG_NODE_659 n324 25.51675
r264 n498 nSEG_NODE_660 25.5168
r265 nSEG_NODE_660 n325 25.51675
r266 n499 nSEG_NODE_661 49.5368
r267 nSEG_NODE_661 n200 49.5366
r268 n500 nSEG_NODE_662 44.0251
r269 nSEG_NODE_662 nSEG_NODE_663 44.0251
r270 nSEG_NODE_663 n208 44.02485
r271 n501 nSEG_NODE_664 36.0867
r272 nSEG_NODE_664 nSEG_NODE_665 36.0867
r273 nSEG_NODE_665 n358 36.08655
r274 n504 nSEG_NODE_666 36.6063
r275 nSEG_NODE_666 n336 36.60605
r276 n508 nSEG_NODE_667 34.0108
r277 nSEG_NODE_667 nSEG_NODE_668 34.0108
r278 nSEG_NODE_668 n131 34.01065
r279 n509 nSEG_NODE_669 32.667
r280 nSEG_NODE_669 n176 32.66695
r281 n511 nSEG_NODE_670 37.9639
r282 nSEG_NODE_670 n345 37.96375
r283 n513 nSEG_NODE_671 27.2721
r284 nSEG_NODE_671 n356 27.27185
r285 n514 nSEG_NODE_672 27.272
r286 nSEG_NODE_672 n357 27.27195
r287 n519 nSEG_NODE_673 44.3405
r288 nSEG_NODE_673 nSEG_NODE_674 44.3405
r289 nSEG_NODE_674 nSEG_NODE_675 44.3405
r290 nSEG_NODE_675 nSEG_NODE_676 44.3405
r291 nSEG_NODE_676 nSEG_NODE_677 44.3405
r292 nSEG_NODE_677 nSEG_NODE_678 44.3405
r293 nSEG_NODE_678 nSEG_NODE_679 44.3405
r294 nSEG_NODE_679 n237 44.3393625
r295 n520 nSEG_NODE_680 48.5505
r296 nSEG_NODE_680 nSEG_NODE_681 48.5505
r297 nSEG_NODE_681 nSEG_NODE_682 48.5505
r298 nSEG_NODE_682 nSEG_NODE_683 48.5505
r299 nSEG_NODE_683 nSEG_NODE_684 48.5505
r300 nSEG_NODE_684 n234 48.54995
r301 n521 nSEG_NODE_685 39.0689
r302 nSEG_NODE_685 n207 39.06875
r303 n523 nSEG_NODE_686 42.2625
r304 nSEG_NODE_686 nSEG_NODE_687 42.2625
r305 nSEG_NODE_687 nSEG_NODE_688 42.2625
r306 nSEG_NODE_688 nSEG_NODE_689 42.2625
r307 nSEG_NODE_689 nSEG_NODE_690 42.2625
r308 nSEG_NODE_690 n192 42.262
r309 n524 nSEG_NODE_691 43.9788
r310 nSEG_NODE_691 nSEG_NODE_692 43.9788
r311 nSEG_NODE_692 nSEG_NODE_693 43.9788
r312 nSEG_NODE_693 nSEG_NODE_694 43.9788
r313 nSEG_NODE_694 n233 43.9788
r314 n526 nSEG_NODE_695 38.5326
r315 nSEG_NODE_695 nSEG_NODE_696 38.5326
r316 nSEG_NODE_696 n123 38.53245
r317 n536 nSEG_NODE_697 48.7401
r318 nSEG_NODE_697 nSEG_NODE_698 48.7401
r319 nSEG_NODE_698 n224 48.73975
r320 n537 nSEG_NODE_699 47.3247
r321 nSEG_NODE_699 nSEG_NODE_700 47.3247
r322 nSEG_NODE_700 nSEG_NODE_701 47.3247
r323 nSEG_NODE_701 n202 47.3242
r324 n538 nSEG_NODE_702 37.3841
r325 nSEG_NODE_702 nSEG_NODE_703 37.3841
r326 nSEG_NODE_703 n252 37.38375
r327 n539 nSEG_NODE_704 31.325
r328 nSEG_NODE_704 n163 31.325
r329 n544 nSEG_NODE_705 38.8076
r330 nSEG_NODE_705 nSEG_NODE_706 38.8076
r331 nSEG_NODE_706 nSEG_NODE_707 38.8076
r332 nSEG_NODE_707 n249 38.8075
r333 n546 nSEG_NODE_708 37.8666
r334 nSEG_NODE_708 n191 37.8666
r335 n547 nSEG_NODE_709 48.0218
r336 nSEG_NODE_709 n167 48.02165
r337 n548 nSEG_NODE_710 27.3518
r338 nSEG_NODE_710 n259 27.35165
r339 n549 nSEG_NODE_711 27.3518
r340 nSEG_NODE_711 n260 27.35165
r341 n550 nSEG_NODE_712 37.5069
r342 nSEG_NODE_712 n272 37.5068
r343 n556 nSEG_NODE_713 49.4274
r344 nSEG_NODE_713 n125 49.42725
r345 n558 nSEG_NODE_714 29.5281
r346 nSEG_NODE_714 n155 29.5281
r347 n560 nSEG_NODE_715 30.5787
r348 nSEG_NODE_715 n316 30.5786
r349 n561 nSEG_NODE_716 30.5787
r350 nSEG_NODE_716 n317 30.5786
r351 n568 nSEG_NODE_717 38.8666
r352 nSEG_NODE_717 n138 38.8665
r353 n570 nSEG_NODE_718 39.2331
r354 nSEG_NODE_718 n168 39.23295
r355 n571 nSEG_NODE_719 35.9139
r356 nSEG_NODE_719 n166 35.9137
r357 n573 nSEG_NODE_720 32.9835
r358 nSEG_NODE_720 n283 32.9832
r359 n578 nSEG_NODE_721 29.6642
r360 nSEG_NODE_721 n285 29.66405
r361 n580 nSEG_NODE_722 29.6642
r362 nSEG_NODE_722 n296 29.66405
r363 n585 nSEG_NODE_723 41.9709
r364 nSEG_NODE_723 nSEG_NODE_724 41.9709
r365 nSEG_NODE_724 nSEG_NODE_725 41.9709
r366 nSEG_NODE_725 n216 41.9705375
r367 n586 nSEG_NODE_726 44.6728
r368 nSEG_NODE_726 nSEG_NODE_727 44.6728
r369 nSEG_NODE_727 n232 44.6727375
r370 n587 nSEG_NODE_728 26.38
r371 nSEG_NODE_728 n142 26.379925
r372 n589 nSEG_NODE_729 42.5431
r373 nSEG_NODE_729 nSEG_NODE_730 42.5431
r374 nSEG_NODE_730 nSEG_NODE_731 42.5431
r375 nSEG_NODE_731 n211 42.542975
r376 n590 nSEG_NODE_732 41.3105
r377 nSEG_NODE_732 nSEG_NODE_733 41.3105
r378 nSEG_NODE_733 nSEG_NODE_734 41.3105
r379 nSEG_NODE_734 n194 41.310325
r380 n594 nSEG_NODE_735 32.6427
r381 nSEG_NODE_735 n288 32.6426
r382 n596 nSEG_NODE_736 32.6427
r383 nSEG_NODE_736 n299 32.6426
r384 n597 nSEG_NODE_737 37.1478
r385 nSEG_NODE_737 nSEG_NODE_738 37.1478
r386 nSEG_NODE_738 n182 37.14765
r387 n598 nSEG_NODE_739 48.1927
r388 nSEG_NODE_739 nSEG_NODE_740 48.1927
r389 nSEG_NODE_740 n153 48.1924
r390 n601 nSEG_NODE_741 40.2532
r391 nSEG_NODE_741 n289 40.25305
r392 n604 nSEG_NODE_742 25.6962
r393 nSEG_NODE_742 n300 25.69605
r394 n606 nSEG_NODE_743 25.6962
r395 nSEG_NODE_743 n301 25.69605
r396 n608 nSEG_NODE_744 43.8606
r397 nSEG_NODE_744 n130 43.86055
r398 n613 nSEG_NODE_745 30.6334
r399 nSEG_NODE_745 n124 30.6333
r400 n625 nSEG_NODE_746 44.3036
r401 nSEG_NODE_746 nSEG_NODE_747 44.3036
r402 nSEG_NODE_747 n231 44.30355
r403 n626 nSEG_NODE_748 41.6541
r404 nSEG_NODE_748 nSEG_NODE_749 41.6541
r405 nSEG_NODE_749 nSEG_NODE_750 41.6541
r406 nSEG_NODE_750 nSEG_NODE_751 41.6541
r407 nSEG_NODE_751 n213 41.6533
r408 n627 nSEG_NODE_752 40.3759
r409 nSEG_NODE_752 n158 40.37585
r410 n628 nSEG_NODE_753 34.3628
r411 nSEG_NODE_753 nSEG_NODE_754 34.3628
r412 nSEG_NODE_754 n183 34.36255
r413 n630 nSEG_NODE_755 34.2017
r414 nSEG_NODE_755 n245 34.20165
r415 n632 nSEG_NODE_756 33.2186
r416 nSEG_NODE_756 n244 33.2185
r417 n633 nSEG_NODE_757 33.2186
r418 nSEG_NODE_757 n255 33.2185
r419 n640 nSEG_NODE_758 43.9732
r420 nSEG_NODE_758 n180 43.97305
r421 n641 nSEG_NODE_759 38.4653
r422 nSEG_NODE_759 nSEG_NODE_760 38.4653
r423 nSEG_NODE_760 nSEG_NODE_761 38.4653
r424 nSEG_NODE_761 n197 38.46495
r425 n643 nSEG_NODE_762 46.4948
r426 nSEG_NODE_762 n246 46.4948
r427 n644 nSEG_NODE_763 26.1072
r428 nSEG_NODE_763 n132 26.1072
r429 n647 nSEG_NODE_764 30.9683
r430 nSEG_NODE_764 n205 30.9683
r431 n648 nSEG_NODE_765 29.9213
r432 nSEG_NODE_765 n164 29.9213
r433 n649 nSEG_NODE_766 49.5309
r434 nSEG_NODE_766 n279 49.5307
r435 n655 nSEG_NODE_767 25.5772
r436 nSEG_NODE_767 n146 25.5771
r437 n658 nSEG_NODE_768 41.7937
r438 nSEG_NODE_768 n258 41.7936
r439 n660 nSEG_NODE_769 41.7937
r440 nSEG_NODE_769 n270 41.7936
r441 n670 nSEG_NODE_770 27.462
r442 nSEG_NODE_770 n290 27.4619
r443 n672 nSEG_NODE_771 27.462
r444 nSEG_NODE_771 n291 27.4619
x0 gin n0 vdd inv0
x1 n0 n363 vdd inv0
x2 n240 n221 vdd inv0
x3 n240 n365 vdd inv0
x4 n220 n366 vdd inv0
x5 n220 n367 vdd inv0
x6 n196 n368 vdd inv0
x7 n368 n369 vdd inv0
x8 n196 n195 vdd inv0
x9 n195 n371 vdd inv0
x10 n195 n372 vdd inv0
x11 n137 n373 vdd inv0
x12 n373 n374 vdd inv0
x13 n137 n375 vdd inv0
x14 n375 n376 vdd inv0
x15 n133 n377 vdd inv0
x16 n377 n378 vdd inv0
x17 n133 n379 vdd inv0
x18 n379 n380 vdd inv0
x19 n128 n381 vdd inv0
x20 n381 n382 vdd inv0
x21 n128 n383 vdd inv0
x22 n383 n384 vdd inv0
x23 n221 n385 vdd inv0
x24 n221 n177 vdd inv0
x25 n177 n387 vdd inv0
x26 n387 n388 vdd inv0
x27 n177 n239 vdd inv0
x28 n239 n390 vdd inv0
x29 n239 n391 vdd inv0
x30 n238 n392 vdd inv0
x31 n238 n228 vdd inv0
x32 n228 n394 vdd inv0
x33 n228 n235 vdd inv0
x34 n235 n396 vdd inv0
x35 n235 n397 vdd inv0
x36 n227 n398 vdd inv0
x37 n227 n399 vdd inv0
x38 n226 n400 vdd inv0
x39 n226 n401 vdd inv0
x40 n204 n402 vdd inv0
x41 n204 n403 vdd inv0
x42 n169 n404 vdd inv0
x43 n404 n405 vdd inv0
x44 n169 n406 vdd inv0
x45 n406 n407 vdd inv0
x46 n185 n408 vdd inv0
x47 n185 n409 vdd inv0
x48 n173 n410 vdd inv0
x49 n410 n411 vdd inv0
x50 n173 n412 vdd inv0
x51 n129 n413 vdd inv0
x52 n129 n414 vdd inv0
x53 n161 n415 vdd inv0
x54 n415 n416 vdd inv0
x55 n161 n417 vdd inv0
x56 n145 n418 vdd inv0
x57 n145 n419 vdd inv0
x58 n181 n420 vdd inv0
x59 n181 n421 vdd inv0
x60 n193 n422 vdd inv0
x61 n193 n423 vdd inv0
x62 n144 n424 vdd inv0
x63 n424 n425 vdd inv0
x64 n144 n426 vdd inv0
x65 n426 n427 vdd inv0
x66 n148 n428 vdd inv0
x67 n148 n187 vdd inv0
x68 n187 n430 vdd inv0
x69 n430 n431 vdd inv0
x70 n187 n432 vdd inv0
x71 n432 n433 vdd inv0
x72 n225 n434 vdd inv0
x73 n225 n435 vdd inv0
x74 n222 n436 vdd inv0
x75 n222 n437 vdd inv0
x76 n217 n438 vdd inv0
x77 n217 n439 vdd inv0
x78 n126 n440 vdd inv0
x79 n440 n441 vdd inv0
x80 n126 n442 vdd inv0
x81 n442 n443 vdd inv0
x82 n179 n444 vdd inv0
x83 n444 n445 vdd inv0
x84 n179 n446 vdd inv0
x85 n152 n447 vdd inv0
x86 n152 n448 vdd inv0
x87 n198 n449 vdd inv0
x88 n198 n450 vdd inv0
x89 n184 n451 vdd inv0
x90 n451 n452 vdd inv0
x91 n184 n453 vdd inv0
x92 n453 n454 vdd inv0
x93 n188 n455 vdd inv0
x94 n455 n456 vdd inv0
x95 n188 n457 vdd inv0
x96 n457 n458 vdd inv0
x97 n218 n459 vdd inv0
x98 n459 n460 vdd inv0
x99 n218 n461 vdd inv0
x100 n199 n462 vdd inv0
x101 n199 n463 vdd inv0
x102 n171 n464 vdd inv0
x103 n464 n465 vdd inv0
x104 n171 n466 vdd inv0
x105 n466 n467 vdd inv0
x106 n172 n468 vdd inv0
x107 n468 n469 vdd inv0
x108 n172 n470 vdd inv0
x109 n149 n471 vdd inv0
x110 n149 n472 vdd inv0
x111 n122 n473 vdd inv0
x112 n473 n474 vdd inv0
x113 n122 n475 vdd inv0
x114 n475 n476 vdd inv0
x115 n230 n477 vdd inv0
x116 n230 n478 vdd inv0
x117 n210 n479 vdd inv0
x118 n210 n480 vdd inv0
x119 n206 n481 vdd inv0
x120 n206 n482 vdd inv0
x121 n160 n483 vdd inv0
x122 n160 n484 vdd inv0
x123 n136 n485 vdd inv0
x124 n136 n486 vdd inv0
x125 n135 n487 vdd inv0
x126 n135 n488 vdd inv0
x127 n140 n489 vdd inv0
x128 n489 n490 vdd inv0
x129 n140 n491 vdd inv0
x130 n491 n492 vdd inv0
x131 n214 n493 vdd inv0
x132 n214 n494 vdd inv0
x133 n156 n495 vdd inv0
x134 n495 n496 vdd inv0
x135 n156 n497 vdd inv0
x136 n497 n498 vdd inv0
x137 n209 n499 vdd inv0
x138 n209 n500 vdd inv0
x139 n208 n501 vdd inv0
x140 n208 n502 vdd inv0
x141 n189 n503 vdd inv0
x142 n503 n504 vdd inv0
x143 n189 n505 vdd inv0
x144 n143 n506 vdd inv0
x145 n143 n507 vdd inv0
x146 n200 n508 vdd inv0
x147 n200 n509 vdd inv0
x148 n176 n510 vdd inv0
x149 n510 n511 vdd inv0
x150 n176 n512 vdd inv0
x151 n159 n513 vdd inv0
x152 n159 n514 vdd inv0
x153 n131 n515 vdd inv0
x154 n515 n516 vdd inv0
x155 n131 n517 vdd inv0
x156 n517 n518 vdd inv0
x157 n236 n519 vdd inv0
x158 n236 n520 vdd inv0
x159 n234 n521 vdd inv0
x160 n234 n223 vdd inv0
x161 n223 n523 vdd inv0
x162 n223 n524 vdd inv0
x163 n233 n127 vdd inv0
x164 n233 n526 vdd inv0
x165 n123 n527 vdd inv0
x166 n527 n528 vdd inv0
x167 n123 n529 vdd inv0
x168 n529 n530 vdd inv0
x169 n127 n531 vdd inv0
x170 n531 n532 vdd inv0
x171 n127 n175 vdd inv0
x172 n175 n212 vdd inv0
x173 n175 n535 vdd inv0
x174 n212 n536 vdd inv0
x175 n212 n537 vdd inv0
x176 n202 n538 vdd inv0
x177 n202 n539 vdd inv0
x178 n163 n540 vdd inv0
x179 n540 n541 vdd inv0
x180 n163 n542 vdd inv0
x181 n542 n543 vdd inv0
x182 n224 n544 vdd inv0
x183 n224 n545 vdd inv0
x184 n219 n546 vdd inv0
x185 n219 n547 vdd inv0
x186 n167 n548 vdd inv0
x187 n167 n549 vdd inv0
x188 n191 n550 vdd inv0
x189 n191 n551 vdd inv0
x190 n147 n552 vdd inv0
x191 n552 n553 vdd inv0
x192 n147 n554 vdd inv0
x193 n554 n555 vdd inv0
x194 n192 n556 vdd inv0
x195 n192 n557 vdd inv0
x196 n174 n558 vdd inv0
x197 n174 n559 vdd inv0
x198 n165 n560 vdd inv0
x199 n165 n561 vdd inv0
x200 n155 n562 vdd inv0
x201 n155 n563 vdd inv0
x202 n125 n564 vdd inv0
x203 n564 n565 vdd inv0
x204 n125 n566 vdd inv0
x205 n566 n567 vdd inv0
x206 n207 n568 vdd inv0
x207 n207 n203 vdd inv0
x208 n203 n570 vdd inv0
x209 n203 n571 vdd inv0
x210 n166 n572 vdd inv0
x211 n572 n573 vdd inv0
x212 n166 n574 vdd inv0
x213 n121 n575 vdd inv0
x214 n121 n576 vdd inv0
x215 n168 n577 vdd inv0
x216 n577 n578 vdd inv0
x217 n168 n579 vdd inv0
x218 n579 n580 vdd inv0
x219 n138 n581 vdd inv0
x220 n138 n582 vdd inv0
x221 n237 n583 vdd inv0
x222 n237 n150 vdd inv0
x223 n150 n585 vdd inv0
x224 n150 n586 vdd inv0
x225 n232 n587 vdd inv0
x226 n232 n229 vdd inv0
x227 n229 n589 vdd inv0
x228 n229 n590 vdd inv0
x229 n194 n190 vdd inv0
x230 n194 n592 vdd inv0
x231 n186 n593 vdd inv0
x232 n593 n594 vdd inv0
x233 n186 n595 vdd inv0
x234 n595 n596 vdd inv0
x235 n190 n597 vdd inv0
x236 n190 n598 vdd inv0
x237 n153 n599 vdd inv0
x238 n153 n600 vdd inv0
x239 n182 n601 vdd inv0
x240 n182 n602 vdd inv0
x241 n157 n603 vdd inv0
x242 n603 n604 vdd inv0
x243 n157 n605 vdd inv0
x244 n605 n606 vdd inv0
x245 n211 n607 vdd inv0
x246 n211 n608 vdd inv0
x247 n130 n609 vdd inv0
x248 n609 n610 vdd inv0
x249 n130 n611 vdd inv0
x250 n611 n612 vdd inv0
x251 n170 n613 vdd inv0
x252 n170 n614 vdd inv0
x253 n139 n615 vdd inv0
x254 n139 n616 vdd inv0
x255 n124 n617 vdd inv0
x256 n124 n618 vdd inv0
x257 n142 n619 vdd inv0
x258 n619 n620 vdd inv0
x259 n142 n621 vdd inv0
x260 n621 n622 vdd inv0
x261 n216 n623 vdd inv0
x262 n216 n215 vdd inv0
x263 n215 n625 vdd inv0
x264 n215 n626 vdd inv0
x265 n213 n627 vdd inv0
x266 n213 n628 vdd inv0
x267 n183 n629 vdd inv0
x268 n629 n630 vdd inv0
x269 n183 n631 vdd inv0
x270 n178 n632 vdd inv0
x271 n178 n633 vdd inv0
x272 n158 n634 vdd inv0
x273 n158 n635 vdd inv0
x274 n151 n636 vdd inv0
x275 n151 n637 vdd inv0
x276 n141 n638 vdd inv0
x277 n141 n639 vdd inv0
x278 n231 n640 vdd inv0
x279 n231 n641 vdd inv0
x280 n197 n642 vdd inv0
x281 n642 n643 vdd inv0
x282 n197 n644 vdd inv0
x283 n132 n645 vdd inv0
x284 n132 n646 vdd inv0
x285 n180 n647 vdd inv0
x286 n180 n648 vdd inv0
x287 n164 n649 vdd inv0
x288 n164 n650 vdd inv0
x289 n154 n651 vdd inv0
x290 n651 n652 vdd inv0
x291 n154 n653 vdd inv0
x292 n653 n654 vdd inv0
x293 n205 n655 vdd inv0
x294 n205 n656 vdd inv0
x295 n201 n657 vdd inv0
x296 n657 n658 vdd inv0
x297 n201 n659 vdd inv0
x298 n659 n660 vdd inv0
x299 n146 n661 vdd inv0
x300 n661 n662 vdd inv0
x301 n146 n663 vdd inv0
x302 n663 n664 vdd inv0
x303 n134 n665 vdd inv0
x304 n665 n666 vdd inv0
x305 n134 n667 vdd inv0
x306 n667 n668 vdd inv0
x307 n162 n669 vdd inv0
x308 n669 n670 vdd inv0
x309 n162 n671 vdd inv0
x310 n671 n672 vdd inv0
*
vdd vdd 0 1.2
vdt gin 0 1.2 pwl(0n 0, 0.2n 0, 0.325n 1.2, 2n 1.2)
*
.ic v(gin)=0
.ic v(n0)=1.2
.ic v(n121)=1.2
.ic v(n122)=0
.ic v(n123)=0
.ic v(n124)=1.2
.ic v(n125)=0
.ic v(n126)=0
.ic v(n127)=0
.ic v(n128)=0
.ic v(n129)=1.2
.ic v(n130)=0
.ic v(n131)=0
.ic v(n132)=1.2
.ic v(n133)=0
.ic v(n134)=0
.ic v(n135)=1.2
.ic v(n136)=1.2
.ic v(n137)=0
.ic v(n138)=1.2
.ic v(n139)=1.2
.ic v(n140)=0
.ic v(n141)=1.2
.ic v(n142)=0
.ic v(n143)=1.2
.ic v(n144)=0
.ic v(n145)=1.2
.ic v(n146)=0
.ic v(n147)=0
.ic v(n148)=1.2
.ic v(n149)=1.2
.ic v(n150)=0
.ic v(n151)=1.2
.ic v(n152)=1.2
.ic v(n153)=1.2
.ic v(n154)=0
.ic v(n155)=1.2
.ic v(n156)=0
.ic v(n157)=0
.ic v(n158)=0
.ic v(n159)=1.2
.ic v(n160)=0
.ic v(n161)=0
.ic v(n162)=0
.ic v(n163)=0
.ic v(n164)=1.2
.ic v(n165)=1.2
.ic v(n166)=0
.ic v(n167)=1.2
.ic v(n168)=0
.ic v(n169)=0
.ic v(n170)=0
.ic v(n171)=0
.ic v(n172)=0
.ic v(n173)=0
.ic v(n174)=0
.ic v(n175)=1.2
.ic v(n176)=0
.ic v(n177)=0
.ic v(n178)=1.2
.ic v(n179)=0
.ic v(n180)=0
.ic v(n181)=0
.ic v(n182)=1.2
.ic v(n183)=0
.ic v(n184)=0
.ic v(n185)=1.2
.ic v(n186)=0
.ic v(n187)=0
.ic v(n188)=0
.ic v(n189)=0
.ic v(n190)=0
.ic v(n191)=1.2
.ic v(n192)=1.2
.ic v(n193)=1.2
.ic v(n194)=1.2
.ic v(n195)=1.2
.ic v(n196)=0
.ic v(n197)=0
.ic v(n198)=1.2
.ic v(n199)=1.2
.ic v(n200)=1.2
.ic v(n201)=0
.ic v(n202)=1.2
.ic v(n203)=1.2
.ic v(n204)=1.2
.ic v(n205)=1.2
.ic v(n206)=1.2
.ic v(n207)=0
.ic v(n208)=1.2
.ic v(n209)=0
.ic v(n210)=0
.ic v(n211)=1.2
.ic v(n212)=0
.ic v(n213)=1.2
.ic v(n214)=1.2
.ic v(n215)=0
.ic v(n216)=1.2
.ic v(n217)=1.2
.ic v(n218)=0
.ic v(n219)=0
.ic v(n220)=1.2
.ic v(n221)=1.2
.ic v(n222)=0
.ic v(n223)=0
.ic v(n224)=1.2
.ic v(n225)=1.2
.ic v(n226)=0
.ic v(n227)=1.2
.ic v(n228)=1.2
.ic v(n229)=0
.ic v(n230)=1.2
.ic v(n231)=1.2
.ic v(n232)=1.2
.ic v(n233)=1.2
.ic v(n234)=1.2
.ic v(n235)=0
.ic v(n236)=0
.ic v(n237)=1.2
.ic v(n238)=0
.ic v(n239)=1.2
.ic v(n240)=0
.ic v(n363)=0
.ic v(n365)=1.2
.ic v(n366)=0
.ic v(n367)=0
.ic v(n368)=1.2
.ic v(n369)=0
.ic v(n371)=0
.ic v(n372)=0
.ic v(n373)=1.2
.ic v(n374)=0
.ic v(n375)=1.2
.ic v(n376)=0
.ic v(n377)=1.2
.ic v(n378)=0
.ic v(n379)=1.2
.ic v(n380)=0
.ic v(n381)=1.2
.ic v(n382)=0
.ic v(n383)=1.2
.ic v(n384)=0
.ic v(n385)=0
.ic v(n387)=1.2
.ic v(n388)=0
.ic v(n390)=0
.ic v(n391)=0
.ic v(n392)=1.2
.ic v(n394)=0
.ic v(n396)=1.2
.ic v(n397)=1.2
.ic v(n398)=0
.ic v(n399)=0
.ic v(n400)=1.2
.ic v(n401)=1.2
.ic v(n402)=0
.ic v(n403)=0
.ic v(n404)=1.2
.ic v(n405)=0
.ic v(n406)=1.2
.ic v(n407)=0
.ic v(n408)=0
.ic v(n409)=0
.ic v(n410)=1.2
.ic v(n411)=0
.ic v(n412)=1.2
.ic v(n413)=0
.ic v(n414)=0
.ic v(n415)=1.2
.ic v(n416)=0
.ic v(n417)=1.2
.ic v(n418)=0
.ic v(n419)=0
.ic v(n420)=1.2
.ic v(n421)=1.2
.ic v(n422)=0
.ic v(n423)=0
.ic v(n424)=1.2
.ic v(n425)=0
.ic v(n426)=1.2
.ic v(n427)=0
.ic v(n428)=0
.ic v(n430)=1.2
.ic v(n431)=0
.ic v(n432)=1.2
.ic v(n433)=0
.ic v(n434)=0
.ic v(n435)=0
.ic v(n436)=1.2
.ic v(n437)=1.2
.ic v(n438)=0
.ic v(n439)=0
.ic v(n440)=1.2
.ic v(n441)=0
.ic v(n442)=1.2
.ic v(n443)=0
.ic v(n444)=1.2
.ic v(n445)=0
.ic v(n446)=1.2
.ic v(n447)=0
.ic v(n448)=0
.ic v(n449)=0
.ic v(n450)=0
.ic v(n451)=1.2
.ic v(n452)=0
.ic v(n453)=1.2
.ic v(n454)=0
.ic v(n455)=1.2
.ic v(n456)=0
.ic v(n457)=1.2
.ic v(n458)=0
.ic v(n459)=1.2
.ic v(n460)=0
.ic v(n461)=1.2
.ic v(n462)=0
.ic v(n463)=0
.ic v(n464)=1.2
.ic v(n465)=0
.ic v(n466)=1.2
.ic v(n467)=0
.ic v(n468)=1.2
.ic v(n469)=0
.ic v(n470)=1.2
.ic v(n471)=0
.ic v(n472)=0
.ic v(n473)=1.2
.ic v(n474)=0
.ic v(n475)=1.2
.ic v(n476)=0
.ic v(n477)=0
.ic v(n478)=0
.ic v(n479)=1.2
.ic v(n480)=1.2
.ic v(n481)=0
.ic v(n482)=0
.ic v(n483)=1.2
.ic v(n484)=1.2
.ic v(n485)=0
.ic v(n486)=0
.ic v(n487)=0
.ic v(n488)=0
.ic v(n489)=1.2
.ic v(n490)=0
.ic v(n491)=1.2
.ic v(n492)=0
.ic v(n493)=0
.ic v(n494)=0
.ic v(n495)=1.2
.ic v(n496)=0
.ic v(n497)=1.2
.ic v(n498)=0
.ic v(n499)=1.2
.ic v(n500)=1.2
.ic v(n501)=0
.ic v(n502)=0
.ic v(n503)=1.2
.ic v(n504)=0
.ic v(n505)=1.2
.ic v(n506)=0
.ic v(n507)=0
.ic v(n508)=0
.ic v(n509)=0
.ic v(n510)=1.2
.ic v(n511)=0
.ic v(n512)=1.2
.ic v(n513)=0
.ic v(n514)=0
.ic v(n515)=1.2
.ic v(n516)=0
.ic v(n517)=1.2
.ic v(n518)=0
.ic v(n519)=1.2
.ic v(n520)=1.2
.ic v(n521)=0
.ic v(n523)=1.2
.ic v(n524)=1.2
.ic v(n526)=0
.ic v(n527)=1.2
.ic v(n528)=0
.ic v(n529)=1.2
.ic v(n530)=0
.ic v(n531)=1.2
.ic v(n532)=0
.ic v(n535)=0
.ic v(n536)=1.2
.ic v(n537)=1.2
.ic v(n538)=0
.ic v(n539)=0
.ic v(n540)=1.2
.ic v(n541)=0
.ic v(n542)=1.2
.ic v(n543)=0
.ic v(n544)=0
.ic v(n545)=0
.ic v(n546)=1.2
.ic v(n547)=1.2
.ic v(n548)=0
.ic v(n549)=0
.ic v(n550)=0
.ic v(n551)=0
.ic v(n552)=1.2
.ic v(n553)=0
.ic v(n554)=1.2
.ic v(n555)=0
.ic v(n556)=0
.ic v(n557)=0
.ic v(n558)=1.2
.ic v(n559)=1.2
.ic v(n560)=0
.ic v(n561)=0
.ic v(n562)=0
.ic v(n563)=0
.ic v(n564)=1.2
.ic v(n565)=0
.ic v(n566)=1.2
.ic v(n567)=0
.ic v(n568)=1.2
.ic v(n570)=0
.ic v(n571)=0
.ic v(n572)=1.2
.ic v(n573)=0
.ic v(n574)=1.2
.ic v(n575)=0
.ic v(n576)=0
.ic v(n577)=1.2
.ic v(n578)=0
.ic v(n579)=1.2
.ic v(n580)=0
.ic v(n581)=0
.ic v(n582)=0
.ic v(n583)=0
.ic v(n585)=1.2
.ic v(n586)=1.2
.ic v(n587)=0
.ic v(n589)=1.2
.ic v(n590)=1.2
.ic v(n592)=0
.ic v(n593)=1.2
.ic v(n594)=0
.ic v(n595)=1.2
.ic v(n596)=0
.ic v(n597)=1.2
.ic v(n598)=1.2
.ic v(n599)=0
.ic v(n600)=0
.ic v(n601)=0
.ic v(n602)=0
.ic v(n603)=1.2
.ic v(n604)=0
.ic v(n605)=1.2
.ic v(n606)=0
.ic v(n607)=0
.ic v(n608)=0
.ic v(n609)=1.2
.ic v(n610)=0
.ic v(n611)=1.2
.ic v(n612)=0
.ic v(n613)=1.2
.ic v(n614)=1.2
.ic v(n615)=0
.ic v(n616)=0
.ic v(n617)=0
.ic v(n618)=0
.ic v(n619)=1.2
.ic v(n620)=0
.ic v(n621)=1.2
.ic v(n622)=0
.ic v(n623)=0
.ic v(n625)=1.2
.ic v(n626)=1.2
.ic v(n627)=0
.ic v(n628)=0
.ic v(n629)=1.2
.ic v(n630)=0
.ic v(n631)=1.2
.ic v(n632)=0
.ic v(n633)=0
.ic v(n634)=1.2
.ic v(n635)=1.2
.ic v(n636)=0
.ic v(n637)=0
.ic v(n638)=0
.ic v(n639)=0
.ic v(n640)=0
.ic v(n641)=0
.ic v(n642)=1.2
.ic v(n643)=0
.ic v(n644)=1.2
.ic v(n645)=0
.ic v(n646)=0
.ic v(n647)=1.2
.ic v(n648)=1.2
.ic v(n649)=0
.ic v(n650)=0
.ic v(n651)=1.2
.ic v(n652)=0
.ic v(n653)=1.2
.ic v(n654)=0
.ic v(n655)=0
.ic v(n656)=0
.ic v(n657)=1.2
.ic v(n658)=0
.ic v(n659)=1.2
.ic v(n660)=0
.ic v(n661)=1.2
.ic v(n662)=0
.ic v(n663)=1.2
.ic v(n664)=0
.ic v(n665)=1.2
.ic v(n666)=0
.ic v(n667)=1.2
.ic v(n668)=0
.ic v(n669)=1.2
.ic v(n670)=0
.ic v(n671)=1.2
.ic v(n672)=0
.ic v(n242)=0
.ic v(n243)=0
.ic v(n244)=0
.ic v(n245)=0
.ic v(n246)=0
.ic v(n247)=0
.ic v(n248)=0
.ic v(n249)=0
.ic v(n250)=0
.ic v(n251)=0
.ic v(n252)=0
.ic v(n253)=0
.ic v(n254)=0
.ic v(n255)=0
.ic v(n256)=0
.ic v(n257)=0
.ic v(n258)=0
.ic v(n259)=0
.ic v(n260)=0
.ic v(n261)=0
.ic v(n262)=0
.ic v(n263)=0
.ic v(n264)=0
.ic v(n265)=0
.ic v(n266)=0
.ic v(n267)=0
.ic v(n268)=0
.ic v(n269)=0
.ic v(n270)=0
.ic v(n271)=0
.ic v(n272)=0
.ic v(n273)=0
.ic v(n274)=0
.ic v(n275)=0
.ic v(n276)=0
.ic v(n277)=0
.ic v(n278)=0
.ic v(n279)=0
.ic v(n280)=0
.ic v(n281)=0
.ic v(n282)=0
.ic v(n283)=0
.ic v(n284)=0
.ic v(n285)=0
.ic v(n286)=0
.ic v(n287)=0
.ic v(n288)=0
.ic v(n289)=0
.ic v(n290)=0
.ic v(n291)=0
.ic v(n292)=0
.ic v(n293)=0
.ic v(n294)=0
.ic v(n295)=0
.ic v(n296)=0
.ic v(n297)=0
.ic v(n298)=0
.ic v(n299)=0
.ic v(n300)=0
.ic v(n301)=0
.ic v(n302)=0
.ic v(n303)=0
.ic v(n304)=0
.ic v(n305)=0
.ic v(n306)=0
.ic v(n307)=0
.ic v(n308)=0
.ic v(n309)=0
.ic v(n310)=0
.ic v(n311)=0
.ic v(n312)=0
.ic v(n313)=0
.ic v(n314)=0
.ic v(n315)=0
.ic v(n316)=0
.ic v(n317)=0
.ic v(n318)=0
.ic v(n319)=0
.ic v(n320)=0
.ic v(n321)=0
.ic v(n322)=0
.ic v(n323)=0
.ic v(n324)=0
.ic v(n325)=0
.ic v(n326)=0
.ic v(n327)=0
.ic v(n328)=0
.ic v(n329)=0
.ic v(n330)=0
.ic v(n331)=0
.ic v(n332)=0
.ic v(n333)=0
.ic v(n334)=0
.ic v(n335)=0
.ic v(n336)=0
.ic v(n337)=0
.ic v(n338)=0
.ic v(n339)=0
.ic v(n340)=0
.ic v(n341)=0
.ic v(n342)=0
.ic v(n343)=0
.ic v(n344)=0
.ic v(n345)=0
.ic v(n346)=0
.ic v(n347)=0
.ic v(n348)=0
.ic v(n349)=0
.ic v(n350)=0
.ic v(n351)=0
.ic v(n352)=0
.ic v(n353)=0
.ic v(n354)=0
.ic v(n355)=0
.ic v(n356)=0
.ic v(n357)=0
.ic v(n358)=0
.ic v(n359)=0
.ic v(n360)=0
.ic v(n361)=0
.ic v(n362)=0
.ic v(nSEG_NODE_552)=1.2
.ic v(nSEG_NODE_553)=1.2
.ic v(nSEG_NODE_554)=1.2
.ic v(nSEG_NODE_555)=1.2
.ic v(nSEG_NODE_556)=1.2
.ic v(nSEG_NODE_557)=1.2
.ic v(nSEG_NODE_558)=1.2
.ic v(nSEG_NODE_559)=1.2
.ic v(nSEG_NODE_560)=1.2
.ic v(nSEG_NODE_561)=1.2
.ic v(nSEG_NODE_562)=1.2
.ic v(nSEG_NODE_563)=1.2
.ic v(nSEG_NODE_564)=1.2
.ic v(nSEG_NODE_565)=1.2
.ic v(nSEG_NODE_566)=1.2
.ic v(nSEG_NODE_567)=1.2
.ic v(nSEG_NODE_568)=1.2
.ic v(nSEG_NODE_569)=1.2
.ic v(nSEG_NODE_570)=1.2
.ic v(nSEG_NODE_571)=1.2
.ic v(nSEG_NODE_572)=1.2
.ic v(nSEG_NODE_573)=1.2
.ic v(nSEG_NODE_574)=1.2
.ic v(nSEG_NODE_575)=1.2
.ic v(nSEG_NODE_576)=1.2
.ic v(nSEG_NODE_577)=1.2
.ic v(nSEG_NODE_578)=1.2
.ic v(nSEG_NODE_579)=1.2
.ic v(nSEG_NODE_580)=1.2
.ic v(nSEG_NODE_581)=1.2
.ic v(nSEG_NODE_582)=1.2
.ic v(nSEG_NODE_583)=1.2
.ic v(nSEG_NODE_584)=1.2
.ic v(nSEG_NODE_585)=1.2
.ic v(nSEG_NODE_586)=1.2
.ic v(nSEG_NODE_587)=1.2
.ic v(nSEG_NODE_588)=1.2
.ic v(nSEG_NODE_589)=1.2
.ic v(nSEG_NODE_590)=1.2
.ic v(nSEG_NODE_591)=1.2
.ic v(nSEG_NODE_592)=1.2
.ic v(nSEG_NODE_593)=1.2
.ic v(nSEG_NODE_594)=1.2
.ic v(nSEG_NODE_595)=1.2
.ic v(nSEG_NODE_596)=1.2
.ic v(nSEG_NODE_597)=1.2
.ic v(nSEG_NODE_598)=1.2
.ic v(nSEG_NODE_599)=1.2
.ic v(nSEG_NODE_600)=1.2
.ic v(nSEG_NODE_601)=1.2
.ic v(nSEG_NODE_602)=1.2
.ic v(nSEG_NODE_603)=1.2
.ic v(nSEG_NODE_604)=1.2
.ic v(nSEG_NODE_605)=1.2
.ic v(nSEG_NODE_606)=1.2
.ic v(nSEG_NODE_607)=1.2
.ic v(nSEG_NODE_608)=1.2
.ic v(nSEG_NODE_609)=1.2
.ic v(nSEG_NODE_610)=1.2
.ic v(nSEG_NODE_611)=1.2
.ic v(nSEG_NODE_612)=1.2
.ic v(nSEG_NODE_613)=1.2
.ic v(nSEG_NODE_614)=1.2
.ic v(nSEG_NODE_615)=1.2
.ic v(nSEG_NODE_616)=1.2
.ic v(nSEG_NODE_617)=1.2
.ic v(nSEG_NODE_618)=1.2
.ic v(nSEG_NODE_619)=1.2
.ic v(nSEG_NODE_620)=1.2
.ic v(nSEG_NODE_621)=1.2
.ic v(nSEG_NODE_622)=1.2
.ic v(nSEG_NODE_623)=1.2
.ic v(nSEG_NODE_624)=1.2
.ic v(nSEG_NODE_625)=1.2
.ic v(nSEG_NODE_626)=1.2
.ic v(nSEG_NODE_627)=1.2
.ic v(nSEG_NODE_628)=1.2
.ic v(nSEG_NODE_629)=1.2
.ic v(nSEG_NODE_630)=1.2
.ic v(nSEG_NODE_631)=1.2
.ic v(nSEG_NODE_632)=1.2
.ic v(nSEG_NODE_633)=1.2
.ic v(nSEG_NODE_634)=1.2
.ic v(nSEG_NODE_635)=1.2
.ic v(nSEG_NODE_636)=1.2
.ic v(nSEG_NODE_637)=1.2
.ic v(nSEG_NODE_638)=1.2
.ic v(nSEG_NODE_639)=1.2
.ic v(nSEG_NODE_640)=1.2
.ic v(nSEG_NODE_641)=1.2
.ic v(nSEG_NODE_642)=1.2
.ic v(nSEG_NODE_643)=1.2
.ic v(nSEG_NODE_644)=1.2
.ic v(nSEG_NODE_645)=1.2
.ic v(nSEG_NODE_646)=1.2
.ic v(nSEG_NODE_647)=1.2
.ic v(nSEG_NODE_648)=1.2
.ic v(nSEG_NODE_649)=1.2
.ic v(nSEG_NODE_650)=1.2
.ic v(nSEG_NODE_651)=1.2
.ic v(nSEG_NODE_652)=1.2
.ic v(nSEG_NODE_653)=1.2
.ic v(nSEG_NODE_654)=1.2
.ic v(nSEG_NODE_655)=1.2
.ic v(nSEG_NODE_656)=1.2
.ic v(nSEG_NODE_657)=1.2
.ic v(nSEG_NODE_658)=1.2
.ic v(nSEG_NODE_659)=1.2
.ic v(nSEG_NODE_660)=1.2
.ic v(nSEG_NODE_661)=1.2
.ic v(nSEG_NODE_662)=1.2
.ic v(nSEG_NODE_663)=1.2
.ic v(nSEG_NODE_664)=1.2
.ic v(nSEG_NODE_665)=1.2
.ic v(nSEG_NODE_666)=1.2
.ic v(nSEG_NODE_667)=1.2
.ic v(nSEG_NODE_668)=1.2
.ic v(nSEG_NODE_669)=1.2
.ic v(nSEG_NODE_670)=1.2
.ic v(nSEG_NODE_671)=1.2
.ic v(nSEG_NODE_672)=1.2
.ic v(nSEG_NODE_673)=1.2
.ic v(nSEG_NODE_674)=1.2
.ic v(nSEG_NODE_675)=1.2
.ic v(nSEG_NODE_676)=1.2
.ic v(nSEG_NODE_677)=1.2
.ic v(nSEG_NODE_678)=1.2
.ic v(nSEG_NODE_679)=1.2
.ic v(nSEG_NODE_680)=1.2
.ic v(nSEG_NODE_681)=1.2
.ic v(nSEG_NODE_682)=1.2
.ic v(nSEG_NODE_683)=1.2
.ic v(nSEG_NODE_684)=1.2
.ic v(nSEG_NODE_685)=1.2
.ic v(nSEG_NODE_686)=1.2
.ic v(nSEG_NODE_687)=1.2
.ic v(nSEG_NODE_688)=1.2
.ic v(nSEG_NODE_689)=1.2
.ic v(nSEG_NODE_690)=1.2
.ic v(nSEG_NODE_691)=1.2
.ic v(nSEG_NODE_692)=1.2
.ic v(nSEG_NODE_693)=1.2
.ic v(nSEG_NODE_694)=1.2
.ic v(nSEG_NODE_695)=1.2
.ic v(nSEG_NODE_696)=1.2
.ic v(nSEG_NODE_697)=1.2
.ic v(nSEG_NODE_698)=1.2
.ic v(nSEG_NODE_699)=1.2
.ic v(nSEG_NODE_700)=1.2
.ic v(nSEG_NODE_701)=1.2
.ic v(nSEG_NODE_702)=1.2
.ic v(nSEG_NODE_703)=1.2
.ic v(nSEG_NODE_704)=1.2
.ic v(nSEG_NODE_705)=1.2
.ic v(nSEG_NODE_706)=1.2
.ic v(nSEG_NODE_707)=1.2
.ic v(nSEG_NODE_708)=1.2
.ic v(nSEG_NODE_709)=1.2
.ic v(nSEG_NODE_710)=1.2
.ic v(nSEG_NODE_711)=1.2
.ic v(nSEG_NODE_712)=1.2
.ic v(nSEG_NODE_713)=1.2
.ic v(nSEG_NODE_714)=1.2
.ic v(nSEG_NODE_715)=1.2
.ic v(nSEG_NODE_716)=1.2
.ic v(nSEG_NODE_717)=1.2
.ic v(nSEG_NODE_718)=1.2
.ic v(nSEG_NODE_719)=1.2
.ic v(nSEG_NODE_720)=1.2
.ic v(nSEG_NODE_721)=1.2
.ic v(nSEG_NODE_722)=1.2
.ic v(nSEG_NODE_723)=1.2
.ic v(nSEG_NODE_724)=1.2
.ic v(nSEG_NODE_725)=1.2
.ic v(nSEG_NODE_726)=1.2
.ic v(nSEG_NODE_727)=1.2
.ic v(nSEG_NODE_728)=1.2
.ic v(nSEG_NODE_729)=1.2
.ic v(nSEG_NODE_730)=1.2
.ic v(nSEG_NODE_731)=1.2
.ic v(nSEG_NODE_732)=1.2
.ic v(nSEG_NODE_733)=1.2
.ic v(nSEG_NODE_734)=1.2
.ic v(nSEG_NODE_735)=1.2
.ic v(nSEG_NODE_736)=1.2
.ic v(nSEG_NODE_737)=1.2
.ic v(nSEG_NODE_738)=1.2
.ic v(nSEG_NODE_739)=1.2
.ic v(nSEG_NODE_740)=1.2
.ic v(nSEG_NODE_741)=1.2
.ic v(nSEG_NODE_742)=1.2
.ic v(nSEG_NODE_743)=1.2
.ic v(nSEG_NODE_744)=1.2
.ic v(nSEG_NODE_745)=1.2
.ic v(nSEG_NODE_746)=1.2
.ic v(nSEG_NODE_747)=1.2
.ic v(nSEG_NODE_748)=1.2
.ic v(nSEG_NODE_749)=1.2
.ic v(nSEG_NODE_750)=1.2
.ic v(nSEG_NODE_751)=1.2
.ic v(nSEG_NODE_752)=1.2
.ic v(nSEG_NODE_753)=1.2
.ic v(nSEG_NODE_754)=1.2
.ic v(nSEG_NODE_755)=1.2
.ic v(nSEG_NODE_756)=1.2
.ic v(nSEG_NODE_757)=1.2
.ic v(nSEG_NODE_758)=1.2
.ic v(nSEG_NODE_759)=1.2
.ic v(nSEG_NODE_760)=1.2
.ic v(nSEG_NODE_761)=1.2
.ic v(nSEG_NODE_762)=1.2
.ic v(nSEG_NODE_763)=1.2
.ic v(nSEG_NODE_764)=1.2
.ic v(nSEG_NODE_765)=1.2
.ic v(nSEG_NODE_766)=1.2
.ic v(nSEG_NODE_767)=1.2
.ic v(nSEG_NODE_768)=1.2
.ic v(nSEG_NODE_769)=1.2
.ic v(nSEG_NODE_770)=1.2
.ic v(nSEG_NODE_771)=1.2
*
.opti nopage temp=75
.width out=240
*
.tran 0.01n 2n 0.0n 0.01n
* .print tran v(gin) v(n0) v(n240) v(n220) v(n196) v(n368) v(n195) v(n137) v(n373) v(n375) v(n133) v(n377) v(n379) v(n128) v(n381) v(n383) v(n221) v(n177) v(n387) v(n239) v(n238) v(n228) v(n235) v(n227) v(n226) v(n204) v(n169) v(n404) v(n406) v(n185) v(n173) v(n410) v(n129) v(n161) v(n415) v(n145) v(n181) v(n193) v(n144) v(n424) v(n426) v(n148) v(n187) v(n430) v(n432) v(n225) v(n222) v(n217) v(n126) v(n440) v(n442) v(n179) v(n444) v(n152) v(n198) v(n184) v(n451) v(n453) v(n188) v(n455) v(n457) v(n218) v(n459) v(n199) v(n171) v(n464) v(n466) v(n172) v(n468) v(n149) v(n122) v(n473) v(n475) v(n230) v(n210) v(n206) v(n160) v(n136) v(n135) v(n140) v(n489) v(n491) v(n214) v(n156) v(n495) v(n497) v(n209) v(n208) v(n189) v(n503) v(n143) v(n200) v(n176) v(n510) v(n159) v(n131) v(n515) v(n517) v(n236) v(n234) v(n223) v(n233) v(n123) v(n527) v(n529) v(n127) v(n531) v(n175) v(n212) v(n202) v(n163) v(n540) v(n542) v(n224) v(n219) v(n167) v(n191) v(n147) v(n552) v(n554) v(n192) v(n174) v(n165) v(n155) v(n125) v(n564) v(n566) v(n207) v(n203) v(n166) v(n572) v(n121) v(n168) v(n577) v(n579) v(n138) v(n237) v(n150) v(n232) v(n229) v(n194) v(n186) v(n593) v(n595) v(n190) v(n153) v(n182) v(n157) v(n603) v(n605) v(n211) v(n130) v(n609) v(n611) v(n170) v(n139) v(n124) v(n142) v(n619) v(n621) v(n216) v(n215) v(n213) v(n183) v(n629) v(n178) v(n158) v(n151) v(n141) v(n231) v(n197) v(n642) v(n132) v(n180) v(n164) v(n154) v(n651) v(n653) v(n205) v(n201) v(n657) v(n659) v(n146) v(n661) v(n663) v(n134) v(n665) v(n667) v(n162) v(n669) v(n671) v(n242) v(n243) v(n244) v(n245) v(n246) v(n247) v(n248) v(n249) v(n250) v(n251) v(n252) v(n253) v(n254) v(n255) v(n256) v(n257) v(n258) v(n259) v(n260) v(n261) v(n262) v(n263) v(n264) v(n265) v(n266) v(n267) v(n268) v(n269) v(n270) v(n271) v(n272) v(n273) v(n274) v(n275) v(n276) v(n277) v(n278) v(n279) v(n280) v(n281) v(n282) v(n283) v(n284) v(n285) v(n286) v(n287) v(n288) v(n289) v(n290) v(n291) v(n292) v(n293) v(n294) v(n295) v(n296) v(n297) v(n298) v(n299) v(n300) v(n301) v(n302) v(n303) v(n304) v(n305) v(n306) v(n307) v(n308) v(n309) v(n310) v(n311) v(n312) v(n313) v(n314) v(n315) v(n316) v(n317) v(n318) v(n319) v(n320) v(n321) v(n322) v(n323) v(n324) v(n325) v(n326) v(n327) v(n328) v(n329) v(n330) v(n331) v(n332) v(n465) v(n334) v(n335) v(n369) v(n337) v(n338) v(n339) v(n340) v(n341) v(n342) v(n343) v(n417) v(n454) v(n346) v(n347) v(n348) v(n349) v(n350) v(n351) v(n352) v(n353) v(n354) v(n355) v(n356) v(n357) v(n358) v(n359) v(n360) v(n361) v(n362)
.print tran all
* plot v(gin) v(n0) v(n240) v(n220) v(n196) v(n368) v(n195) v(n137) v(n373) v(n375) v(n133) v(n377) v(n379) v(n128) v(n381) v(n383) v(n221) v(n177) v(n387) v(n239) v(n238) v(n228) v(n235) v(n227) v(n226) v(n204) v(n169) v(n404) v(n406) v(n185) v(n173) v(n410) v(n129) v(n161) v(n415) v(n145) v(n181) v(n193) v(n144) v(n424) v(n426) v(n148) v(n187) v(n430) v(n432) v(n225) v(n222) v(n217) v(n126) v(n440) v(n442) v(n179) v(n444) v(n152) v(n198) v(n184) v(n451) v(n453) v(n188) v(n455) v(n457) v(n218) v(n459) v(n199) v(n171) v(n464) v(n466) v(n172) v(n468) v(n149) v(n122) v(n473) v(n475) v(n230) v(n210) v(n206) v(n160) v(n136) v(n135) v(n140) v(n489) v(n491) v(n214) v(n156) v(n495) v(n497) v(n209) v(n208) v(n189) v(n503) v(n143) v(n200) v(n176) v(n510) v(n159) v(n131) v(n515) v(n517) v(n236) v(n234) v(n223) v(n233) v(n123) v(n527) v(n529) v(n127) v(n531) v(n175) v(n212) v(n202) v(n163) v(n540) v(n542) v(n224) v(n219) v(n167) v(n191) v(n147) v(n552) v(n554) v(n192) v(n174) v(n165) v(n155) v(n125) v(n564) v(n566) v(n207) v(n203) v(n166) v(n572) v(n121) v(n168) v(n577) v(n579) v(n138) v(n237) v(n150) v(n232) v(n229) v(n194) v(n186) v(n593) v(n595) v(n190) v(n153) v(n182) v(n157) v(n603) v(n605) v(n211) v(n130) v(n609) v(n611) v(n170) v(n139) v(n124) v(n142) v(n619) v(n621) v(n216) v(n215) v(n213) v(n183) v(n629) v(n178) v(n158) v(n151) v(n141) v(n231) v(n197) v(n642) v(n132) v(n180) v(n164) v(n154) v(n651) v(n653) v(n205) v(n201) v(n657) v(n659) v(n146) v(n661) v(n663) v(n134) v(n665) v(n667) v(n162) v(n669) v(n671) v(n242) v(n243) v(n244) v(n245) v(n246) v(n247) v(n248) v(n249) v(n250) v(n251) v(n252) v(n253) v(n254) v(n255) v(n256) v(n257) v(n258) v(n259) v(n260) v(n261) v(n262) v(n263) v(n264) v(n265) v(n266) v(n267) v(n268) v(n269) v(n270) v(n271) v(n272) v(n273) v(n274) v(n275) v(n276) v(n277) v(n278) v(n279) v(n280) v(n281) v(n282) v(n283) v(n284) v(n285) v(n286) v(n287) v(n288) v(n289) v(n290) v(n291) v(n292) v(n293) v(n294) v(n295) v(n296) v(n297) v(n298) v(n299) v(n300) v(n301) v(n302) v(n303) v(n304) v(n305) v(n306) v(n307) v(n308) v(n309) v(n310) v(n311) v(n312) v(n313) v(n314) v(n315) v(n316) v(n317) v(n318) v(n319) v(n320) v(n321) v(n322) v(n323) v(n324) v(n325) v(n326) v(n327) v(n328) v(n329) v(n330) v(n331) v(n332) v(n465) v(n334) v(n335) v(n369) v(n337) v(n338) v(n339) v(n340) v(n341) v(n342) v(n343) v(n417) v(n454) v(n346) v(n347) v(n348) v(n349) v(n350) v(n351) v(n352) v(n353) v(n354) v(n355) v(n356) v(n357) v(n358) v(n359) v(n360) v(n361) v(n362)
.end
